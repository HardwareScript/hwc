* Hardware Script Pure Circuit (DUT)
* Space: CMOS_Inverter_Space
* Generated by hwc v0.2.1
* Format: SPICE3

* ========================================
* PDK SUBCIRCUIT: sky130_fd_pr__pfet_01v8
* ========================================
* Subcircuit 'sky130_fd_pr__pfet_01v8' uses foundry model
.include "sky130_fd_pr/models/sky130_fd_pr__pfet_01v8.model.spice"

* ========================================
* PDK SUBCIRCUIT: sky130_fd_pr__nfet_01v8
* ========================================
* Subcircuit 'sky130_fd_pr__nfet_01v8' uses foundry model
.include "sky130_fd_pr/models/sky130_fd_pr__nfet_01v8.model.spice"

* ========================================
* NETS
* ========================================
* Net: In (pour: NMOS_Gate, material: Polysilicon, z: 150nm)
* Net: In (pour: PMOS_Gate, material: Polysilicon, z: 150nm)
* Net: In (pour: Gate_Bridge, material: Polysilicon, z: 150nm)
* Net: In (pour: Gate_Input_Head, material: Polysilicon, z: 150nm)
* Net: In (pour: Gate_Contact_LI, material: Titanium_Nitride, z: 530nm)
* Net: In (pour: Gate_Contact_M1, material: Aluminum, z: 780nm)
* Net: VSS (pour: NMOS_Source_LI, material: Titanium_Nitride, z: 530nm)
* Net: VSS (pour: NMOS_Source_M1, material: Aluminum, z: 780nm)
* Net: Out (pour: NMOS_Drain_LI, material: Titanium_Nitride, z: 530nm)
* Net: VDD (pour: PMOS_Source_LI, material: Titanium_Nitride, z: 530nm)
* Net: VDD (pour: PMOS_Source_M1, material: Aluminum, z: 780nm)
* Net: Out (pour: PMOS_Drain_LI, material: Titanium_Nitride, z: 530nm)
* Net: Out (pour: Output_LI_Strap, material: Titanium_Nitride, z: 530nm)
* Net: Out (pour: Output_M1_Pad, material: Aluminum, z: 780nm)
* Net: Out (pour: Output_M1_Bridge, material: Aluminum, z: 780nm)
* Net: VSS (pour: Sub_Tap_Diff, material: P_Plus_Diffusion, z: 0nm)
* Net: VSS (pour: Sub_Tap_LI, material: Titanium_Nitride, z: 530nm)
* Net: VSS (pour: Sub_Tap_M1, material: Aluminum, z: 780nm)
* Net: VDD (pour: Well_Tap_Diff, material: N_Plus_Diffusion, z: 0nm)
* Net: VDD (pour: Well_Tap_LI, material: Titanium_Nitride, z: 530nm)
* Net: VDD (pour: Well_Tap_M1, material: Aluminum, z: 780nm)
* Net: VDD (pour: VDD_Pad, material: Aluminum, z: 780nm)
* Net: VSS (pour: VSS_Pad, material: Aluminum, z: 780nm)
* Net: In (pour: Input_Pad, material: Aluminum, z: 780nm)
* Net: Out (pour: Output_Pad, material: Aluminum, z: 780nm)
* Net: VDD (width=140nm, material=Tungsten)
*   Connected pins:
*     - PMOS_Source_LI.anchor
*     - PMOS_Source_LI.__virtual_PMOS_Source_LI
*     - PMOS_Source_M1.anchor
*     - PMOS_Source_M1.__virtual_PMOS_Source_M1
*     - PMOS_S_Via_Diff_0.__virtual_PMOS_S_Via_Diff_0
*     - PMOS_S_Via_M1_0.__virtual_PMOS_S_Via_M1_0
*     - PMOS_S_Via_Diff_1.__virtual_PMOS_S_Via_Diff_1
*     - PMOS_S_Via_M1_1.__virtual_PMOS_S_Via_M1_1
*     - PMOS_S_Via_Diff_2.__virtual_PMOS_S_Via_Diff_2
*     - PMOS_S_Via_M1_2.__virtual_PMOS_S_Via_M1_2
*     - Well_Tap_Diff.anchor
*     - Well_Tap_Diff.__virtual_Well_Tap_Diff
*     - Well_Tap_LI.anchor
*     - Well_Tap_LI.__virtual_Well_Tap_LI
*     - Well_Tap_M1.anchor
*     - Well_Tap_M1.__virtual_Well_Tap_M1
*     - Well_Tap_Licon.__virtual_Well_Tap_Licon
*     - Well_Tap_Mcon.__virtual_Well_Tap_Mcon
*     - VDD_Pad.anchor
*     - VDD_Pad.__virtual_VDD_Pad
* Net: VSS (width=140nm, material=Tungsten)
*   Connected pins:
*     - NMOS_Source_LI.anchor
*     - NMOS_Source_LI.__virtual_NMOS_Source_LI
*     - NMOS_Source_M1.anchor
*     - NMOS_Source_M1.__virtual_NMOS_Source_M1
*     - NMOS_S_Via_Diff_0.__virtual_NMOS_S_Via_Diff_0
*     - NMOS_S_Via_M1_0.__virtual_NMOS_S_Via_M1_0
*     - NMOS_S_Via_Diff_1.__virtual_NMOS_S_Via_Diff_1
*     - NMOS_S_Via_M1_1.__virtual_NMOS_S_Via_M1_1
*     - Sub_Tap_Diff.anchor
*     - Sub_Tap_Diff.__virtual_Sub_Tap_Diff
*     - Sub_Tap_LI.anchor
*     - Sub_Tap_LI.__virtual_Sub_Tap_LI
*     - Sub_Tap_M1.anchor
*     - Sub_Tap_M1.__virtual_Sub_Tap_M1
*     - Sub_Tap_Licon.__virtual_Sub_Tap_Licon
*     - Sub_Tap_Mcon.__virtual_Sub_Tap_Mcon
*     - VSS_Pad.anchor
*     - VSS_Pad.__virtual_VSS_Pad
* Net: In (width=140nm, material=Tungsten)
*   Connected pins:
*     - NMOS_Gate.anchor
*     - NMOS_Gate.__virtual_NMOS_Gate
*     - PMOS_Gate.anchor
*     - PMOS_Gate.__virtual_PMOS_Gate
*     - Gate_Bridge.anchor
*     - Gate_Bridge.__virtual_Gate_Bridge
*     - Gate_Input_Head.anchor
*     - Gate_Input_Head.__virtual_Gate_Input_Head
*     - Gate_Contact_LI.anchor
*     - Gate_Contact_LI.__virtual_Gate_Contact_LI
*     - Gate_Contact_M1.anchor
*     - Gate_Contact_M1.__virtual_Gate_Contact_M1
*     - Gate_Via_Poly_LI.__virtual_Gate_Via_Poly_LI
*     - Gate_Via_LI_M1.__virtual_Gate_Via_LI_M1
*     - Input_Pad.anchor
*     - Input_Pad.__virtual_Input_Pad
* Net: Out (width=140nm, material=Tungsten)
*   Connected pins:
*     - NMOS_Drain_LI.anchor
*     - NMOS_Drain_LI.__virtual_NMOS_Drain_LI
*     - NMOS_D_Via_Diff_0.__virtual_NMOS_D_Via_Diff_0
*     - NMOS_D_Via_Diff_1.__virtual_NMOS_D_Via_Diff_1
*     - PMOS_Drain_LI.anchor
*     - PMOS_Drain_LI.__virtual_PMOS_Drain_LI
*     - PMOS_D_Via_Diff_0.__virtual_PMOS_D_Via_Diff_0
*     - PMOS_D_Via_Diff_1.__virtual_PMOS_D_Via_Diff_1
*     - PMOS_D_Via_Diff_2.__virtual_PMOS_D_Via_Diff_2
*     - Output_LI_Strap.anchor
*     - Output_LI_Strap.__virtual_Output_LI_Strap
*     - Output_M1_Pad.anchor
*     - Output_M1_Pad.__virtual_Output_M1_Pad
*     - Output_Via_M1_0.__virtual_Output_Via_M1_0
*     - Output_Via_M1_1.__virtual_Output_Via_M1_1
*     - Output_M1_Bridge.anchor
*     - Output_M1_Bridge.__virtual_Output_M1_Bridge
*     - Output_Bridge_Bot_Via.__virtual_Output_Bridge_Bot_Via
*     - Output_Bridge_Top_Via.__virtual_Output_Bridge_Top_Via
*     - Output_Pad.anchor
*     - Output_Pad.__virtual_Output_Pad

* ========================================
* EXTRACTED DEVICES
* ========================================
XM_PMOS nOut_diff_1 nIn_poly nVDD_diff nVDD_diff sky130_fd_pr__pfet_01v8 W=2.00u L=0.15u AD=1.50p AS=1.50p PD=5.50u PS=5.50u NRD=0.37 NRS=0.37 SA=0.75u SB=0.75u
XM_NMOS nOut_diff_0 nIn_poly nVSS_diff nVSS_diff sky130_fd_pr__nfet_01v8 W=1.00u L=0.15u AD=0.75p AS=0.75p PD=3.50u PS=3.50u NRD=0.75 NRS=0.75 SA=0.75u SB=0.75u

* ========================================
* INTEGRATED TRACE PARASITICS
* ========================================
* Via/Contact resistance
Rvia_VDD_diff_li1 nVDD_li1 nVDD_diff 3.998148e1
* Via/Contact resistance
Rvia_VDD_li1_metal1 nVDD_metal1 nVDD_li1 5.000439e0
* Via/Contact resistance
Rvia_VSS_diff_li1 nVSS_li1 nVSS_diff 5.330865e1
* Via/Contact resistance
Rvia_VSS_li1_metal1 nVSS_metal1 nVSS_li1 6.667252e0
* Via/Contact resistance
Rvia_In_poly_li1 nIn_li1 nIn_poly 1.000088e2
* Via/Contact resistance
Rvia_In_li1_metal1 nIn_metal1 nIn_li1 2.000176e1
* Via/Contact resistance
Rvia_Out_diff_li1_0 nOut_li1_0 nOut_diff_0 7.996297e1
* Via/Contact resistance
Rvia_Out_li1_metal1_0 nOut_metal1_0 nOut_li1_0 2.000176e1
* Via/Contact resistance
Rvia_Out_diff_li1_1 nOut_li1_1 nOut_diff_1 5.330865e1
* Via/Contact resistance
Rvia_Out_li1_metal1_1 nOut_metal1_1 nOut_li1_1 6.667252e0
* Trace resistance
Rtr_In_0_0 nIn_metal1 In 7.833333e-1
* Ground capacitance
Cgnd_In_0_0 In VSS 9.208355e-17
* Trace resistance
Rtr_VDD_1_0 VDD nVDD_metal1 7.441667e-1
* Ground capacitance
Cgnd_VDD_1_0 nVDD_metal1 VSS 8.747938e-17
* Ground capacitance
Cgnd_VDD_1_1 nVDD_metal1 VSS 4.834387e-17
* Trace resistance
Rtr_Out_2_0 nOut_metal1_1 Out 3.720833e-1
* Ground capacitance
Cgnd_Out_2_0 Out VSS 1.749588e-16
* Trace resistance
Rtr_VSS_3_0 VSS nVSS_metal1 7.441667e-1
* Lateral coupling capacitance
Cc_In_VDD_0_2 In nVDD_metal1 3.014585e-17
* Ground capacitance
Cgnd_pour_Gate_Contact_LI nIn_li1 VSS 2.762507e-17
* Ground capacitance
Cgnd_pour_Gate_Contact_M1 nIn_metal1 VSS 3.683342e-17
* Trace resistance
Rpour_NMOS_Source_M1 nVSS_metal1 nVSS_metal1_strap 1.958333e-1
* Ground capacitance
Cgnd_pour_PMOS_Source_M1 nVDD_metal1 VSS 1.841671e-16
* Ground capacitance
Cgnd_pour_Output_LI_Strap nOut_li1_1 VSS 4.489073e-16
* Trace resistance
Rbus_Output_LI_Strap_0 nOut_li1_0 nOut_li1_1 4.687500e2
* Ground capacitance
Cgnd_pour_Output_M1_Pad nOut_metal1_1 VSS 1.473337e-16
* Trace resistance
Rpour_Output_M1_Pad nOut_metal1 nOut_metal1_strap 7.833333e-2
* Ground capacitance
Cgnd_pour_Output_M1_Bridge nOut_metal1_1 VSS 5.985431e-16
* Trace resistance
Rbus_Output_M1_Bridge_0 nOut_metal1_0 nOut_metal1_1 8.159722e-1
* Trace resistance
Rpour_Sub_Tap_LI nVSS_li1 nVSS_li1_strap 4.500000e1
* Trace resistance
Rpour_Sub_Tap_M1 nVSS_metal1 nVSS_metal1_strap 7.833333e-2
* Ground capacitance
Cgnd_pour_Well_Tap_LI nVDD_li1 VSS 1.553910e-17
* Trace resistance
Rpour_Well_Tap_LI nVDD_li1 nVDD_li1_strap 4.500000e1
* Ground capacitance
Cgnd_pour_Well_Tap_M1 nVDD_metal1 VSS 2.071880e-17
* Trace resistance
Rpour_Well_Tap_M1 nVDD_metal1 nVDD_metal1_strap 7.833333e-2
* Ground capacitance
Cgnd_pour_VDD_Pad VDD VSS 3.315008e-16
* Ground capacitance
Cgnd_pour_Input_Pad In VSS 3.315008e-16
* Ground capacitance
Cgnd_pour_Output_Pad Out VSS 3.315008e-16

* Total parasitic elements: 38

.end
