* Hardware Script Pure Circuit (DUT)
* Space: Via_Cutout_Test_Space
* Generated by hwc v0.1.6
* Format: SPICE3

* ========================================
* NETS
* ========================================
* Net: TestNet (pour: Bottom_Pad, material: Silicon_P, z: 0.0000mm)
* Net: TestNet (pour: Top_Pad, material: Aluminum, z: 0.0005mm)
* Net: TestNet (width=200nm, material=Silicon_Dioxide)
*   Connected pins:
*     - Bottom_Pad.anchor
*     - Bottom_Pad.__virtual_Bottom_Pad
*     - Top_Pad.anchor
*     - Top_Pad.__virtual_Top_Pad
*     - Via_Center.__virtual_Via_Center

* ========================================
* COMPONENTS (Schematic-Level Subcircuits)
* ========================================
XBottom_Pad TestNet TestNet Pour(Silicon_P)
XTop_Pad TestNet TestNet Pour(Aluminum)
XVia_Center TestNet Contact(Titanium_Silicide)

* ========================================
* DEVICE EXTRACTION REQUIRES EXPLICIT BINDINGS
* Use 'device: DeviceName.terminal' property
* ========================================

.end
