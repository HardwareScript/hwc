* Hardware Script Transient Waveform Test
* Space: Simple_Diode_Space
* Generated by hwc v0.1.6
* Format: SPICE3

* ========================================
* NETS
* ========================================
* Net: Anode_In (pour: Contact_Anode, material: Aluminum, z: 0.0000mm)
* Net: Cathode_Out (pour: Contact_Cathode, material: Aluminum, z: 0.0000mm)
* Net: Anode_In (pour: Anode_Pad, material: Aluminum, z: 0.0000mm)
* Net: Cathode_Out (pour: Cathode_Pad, material: Aluminum, z: 0.0000mm)
* Net: Anode_In (width=200nm, material=Silicon_N)
*   Connected pins:
*     - Contact_Anode.anchor
*     - Contact_Anode.__virtual_Contact_Anode
*     - Via_Anode.__virtual_Via_Anode
*     - Anode_Pad.anchor
*     - Anode_Pad.__virtual_Anode_Pad
*     - Anode_Pad.__virtual_Anode_Pad
*     - Contact_Anode.__virtual_Contact_Anode
*     - Anode_Pad.__virtual_Anode_Pad
*     - Contact_Anode.__virtual_Contact_Anode
* Net: Cathode_Out (width=200nm, material=Silicon_N)
*   Connected pins:
*     - Contact_Cathode.anchor
*     - Contact_Cathode.__virtual_Contact_Cathode
*     - Via_Cathode.__virtual_Via_Cathode
*     - Cathode_Pad.anchor
*     - Cathode_Pad.__virtual_Cathode_Pad
*     - Contact_Cathode.__virtual_Contact_Cathode
*     - Cathode_Pad.__virtual_Cathode_Pad
*     - Contact_Cathode.__virtual_Contact_Cathode
*     - Cathode_Pad.__virtual_Cathode_Pad
* Net: TEMP_NET (width=200nm, material=Silicon_N)

* ========================================
* EXTRACTED DEVICES
* ========================================
DD1 nAnode_In_dev nCathode_Out_dev DMOD

* ========================================
* INTEGRATED TRACE PARASITICS
* ========================================
* Trace resistance
RRtr_Anode_In_0 nAnode_In_entry nAnode_In_dev 7.896000e0
* Ground capacitance
CCgnd_Anode_In_0 nAnode_In_dev 0 2.417193e-17
* Trace resistance
RRtr_Cathode_Out_0 nCathode_Out_entry nCathode_Out_dev 7.896000e0
* Ground capacitance
CCgnd_Cathode_Out_0 nCathode_Out_dev 0 2.417193e-17

* Total parasitic elements: 4

* ========================================
* STIMULUS & ANALYSIS
* ========================================
V_Anode_In nAnode_In_entry 0 DC 1.800
.tran 200ns
.end
