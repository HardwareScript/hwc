* Hardware Script Transient Waveform Test
* Space: CMOS_Inverter_Space
* Generated by hwc v0.2.1
* Format: SPICE3

.include "circuit.sp"

* ========================================
* STIMULUS & ANALYSIS
* ========================================
V_VDD VDD 0 DC 1.800
V_VSS VSS 0 DC 0.000
V_In In 0 PULSE(0.0 1.800 0.0 5.000e-13 5.000e-13 9.000e-10 2.000e-9)
.tran 5.000e-12 1.000e-8
.end
