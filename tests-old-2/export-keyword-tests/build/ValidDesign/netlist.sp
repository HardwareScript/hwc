* Hardware Script Native Netlist: ValidDesign
* Generated by hwc v0.1.6 (Syntax Unification)
* Format: SPICE3

* ========================================
* NETS
* ========================================
* Net: A (pour: PadA, material: Aluminum, z: 0.0001mm)
* Net: B (pour: PadB, material: PublicCopper, z: 0.0001mm)
* Net: A (width=180nm, material=Aluminum)
*   Connected pins:
*     - PadA.__virtual_PadA
*     - PadA.__virtual_PadA
*     - PadB.__virtual_PadB
*     - PadA.__virtual_PadA
*     - PadB.__virtual_PadB
* Net: B (width=180nm, material=Aluminum)
*   Connected pins:
*     - PadB.__virtual_PadB
* Net: TEMP_NET (width=180nm, material=Aluminum)

* ========================================
* AUTOMATIC STIMULUS & MODELS
* ========================================
Vgnd GND 0 0
.end
