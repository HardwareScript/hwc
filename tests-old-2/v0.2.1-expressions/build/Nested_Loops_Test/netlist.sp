* Hardware Script Native Netlist: Nested_Loops_Test
* Generated by hwc v0.1.6 (Syntax Unification)
* Format: SPICE3

* ========================================
* NETS
* ========================================
* Net: MATRIX (pour: L0_R0_C0, material: Copper, z: 0.0010mm)
* Net: MATRIX (pour: L0_R0_C1, material: Copper, z: 0.0010mm)
* Net: MATRIX (pour: L0_R0_C2, material: Copper, z: 0.0010mm)
* Net: MATRIX (pour: L0_R1_C0, material: Copper, z: 0.0010mm)
* Net: MATRIX (pour: L0_R1_C1, material: Copper, z: 0.0010mm)
* Net: MATRIX (pour: L0_R1_C2, material: Copper, z: 0.0010mm)
* Net: MATRIX (pour: L0_R2_C0, material: Copper, z: 0.0010mm)
* Net: MATRIX (pour: L0_R2_C1, material: Copper, z: 0.0010mm)
* Net: MATRIX (pour: L0_R2_C2, material: Copper, z: 0.0010mm)
* Net: MATRIX (pour: L1_R0_C0, material: Aluminum, z: 0.0020mm)
* Net: MATRIX (pour: L1_R0_C1, material: Aluminum, z: 0.0020mm)
* Net: MATRIX (pour: L1_R0_C2, material: Aluminum, z: 0.0020mm)
* Net: MATRIX (pour: L1_R1_C0, material: Aluminum, z: 0.0020mm)
* Net: MATRIX (pour: L1_R1_C1, material: Aluminum, z: 0.0020mm)
* Net: MATRIX (pour: L1_R1_C2, material: Aluminum, z: 0.0020mm)
* Net: MATRIX (pour: L1_R2_C0, material: Aluminum, z: 0.0020mm)
* Net: MATRIX (pour: L1_R2_C1, material: Aluminum, z: 0.0020mm)
* Net: MATRIX (pour: L1_R2_C2, material: Aluminum, z: 0.0020mm)
* Net: MATRIX (pour: L2_R0_C0, material: Tungsten, z: 0.0030mm)
* Net: MATRIX (pour: L2_R0_C1, material: Tungsten, z: 0.0030mm)
* Net: MATRIX (pour: L2_R0_C2, material: Tungsten, z: 0.0030mm)
* Net: MATRIX (pour: L2_R1_C0, material: Tungsten, z: 0.0030mm)
* Net: MATRIX (pour: L2_R1_C1, material: Tungsten, z: 0.0030mm)
* Net: MATRIX (pour: L2_R1_C2, material: Tungsten, z: 0.0030mm)
* Net: MATRIX (pour: L2_R2_C0, material: Tungsten, z: 0.0030mm)
* Net: MATRIX (pour: L2_R2_C1, material: Tungsten, z: 0.0030mm)
* Net: MATRIX (pour: L2_R2_C2, material: Tungsten, z: 0.0030mm)
* Net: MATRIX (width=200nm, material=Tungsten)
*   Connected pins:
*     - L0_R0_C0.__virtual_L0_R0_C0
*     - L0_R0_C1.__virtual_L0_R0_C1
*     - L0_R0_C2.__virtual_L0_R0_C2
*     - L0_R1_C0.__virtual_L0_R1_C0
*     - L0_R1_C1.__virtual_L0_R1_C1
*     - L0_R1_C2.__virtual_L0_R1_C2
*     - L0_R2_C0.__virtual_L0_R2_C0
*     - L0_R2_C1.__virtual_L0_R2_C1
*     - L0_R2_C2.__virtual_L0_R2_C2
*     - L1_R0_C0.__virtual_L1_R0_C0
*     - L1_R0_C1.__virtual_L1_R0_C1
*     - L1_R0_C2.__virtual_L1_R0_C2
*     - L1_R1_C0.__virtual_L1_R1_C0
*     - L1_R1_C1.__virtual_L1_R1_C1
*     - L1_R1_C2.__virtual_L1_R1_C2
*     - L1_R2_C0.__virtual_L1_R2_C0
*     - L1_R2_C1.__virtual_L1_R2_C1
*     - L1_R2_C2.__virtual_L1_R2_C2
*     - L2_R0_C0.__virtual_L2_R0_C0
*     - L2_R0_C1.__virtual_L2_R0_C1
*     - L2_R0_C2.__virtual_L2_R0_C2
*     - L2_R1_C0.__virtual_L2_R1_C0
*     - L2_R1_C1.__virtual_L2_R1_C1
*     - L2_R1_C2.__virtual_L2_R1_C2
*     - L2_R2_C0.__virtual_L2_R2_C0
*     - L2_R2_C1.__virtual_L2_R2_C1
*     - L2_R2_C2.__virtual_L2_R2_C2

* ========================================
* COMPONENTS (Schematic-Level Subcircuits)
* ========================================
XL0_R0_C0 MATRIX Plane(Copper)
XL0_R0_C1 MATRIX Plane(Copper)
XL0_R0_C2 MATRIX Plane(Copper)
XL0_R1_C0 MATRIX Plane(Copper)
XL0_R1_C1 MATRIX Plane(Copper)
XL0_R1_C2 MATRIX Plane(Copper)
XL0_R2_C0 MATRIX Plane(Copper)
XL0_R2_C1 MATRIX Plane(Copper)
XL0_R2_C2 MATRIX Plane(Copper)
XL1_R0_C0 MATRIX Plane(Aluminum)
XL1_R0_C1 MATRIX Plane(Aluminum)
XL1_R0_C2 MATRIX Plane(Aluminum)
XL1_R1_C0 MATRIX Plane(Aluminum)
XL1_R1_C1 MATRIX Plane(Aluminum)
XL1_R1_C2 MATRIX Plane(Aluminum)
XL1_R2_C0 MATRIX Plane(Aluminum)
XL1_R2_C1 MATRIX Plane(Aluminum)
XL1_R2_C2 MATRIX Plane(Aluminum)
XL2_R0_C0 MATRIX Plane(Tungsten)
XL2_R0_C1 MATRIX Plane(Tungsten)
XL2_R0_C2 MATRIX Plane(Tungsten)
XL2_R1_C0 MATRIX Plane(Tungsten)
XL2_R1_C1 MATRIX Plane(Tungsten)
XL2_R1_C2 MATRIX Plane(Tungsten)
XL2_R2_C0 MATRIX Plane(Tungsten)
XL2_R2_C1 MATRIX Plane(Tungsten)
XL2_R2_C2 MATRIX Plane(Tungsten)

* ========================================
* DEVICE EXTRACTION REQUIRES EXPLICIT BINDINGS
* Use 'device: DeviceName.terminal' property
* ========================================

.end
