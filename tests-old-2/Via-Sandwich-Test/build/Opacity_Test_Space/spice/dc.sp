* Hardware Script DC Operating Point Test
* Space: Opacity_Test_Space
* Generated by hwc v0.1.6
* Format: SPICE3

* ========================================
* NETS
* ========================================
* Net: TestNet (pour: Poly_Block, material: Polysilicon, z: 0.0000mm)
* Net: TestNet (pour: Aluminum_Block, material: Aluminum, z: 0.0007mm)
* Net: TestNet (width=200nm, material=Tungsten)
*   Connected pins:
*     - Poly_Block.anchor
*     - Poly_Block.__virtual_Poly_Block
*     - Aluminum_Block.anchor
*     - Aluminum_Block.__virtual_Aluminum_Block

* ========================================
* COMPONENTS (Schematic-Level Subcircuits)
* ========================================
XPoly_Block TestNet TestNet Pour(Polysilicon)
XAluminum_Block TestNet TestNet Pour(Aluminum)

* ========================================
* DEVICE EXTRACTION REQUIRES EXPLICIT BINDINGS
* Use 'device: DeviceName.terminal' property
* ========================================

* ========================================
* STIMULUS & ANALYSIS
* ========================================
.op
.end
