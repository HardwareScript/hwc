* Hardware Script Pure Circuit (DUT)
* Space: Via_Sandwich_Space
* Generated by hwc v0.1.6
* Format: SPICE3

* ========================================
* NETS
* ========================================
* Net: TestNet (pour: Bottom_Pad, material: Polysilicon, z: 0.0000mm)
* Net: TestNet (pour: Top_Pad, material: Aluminum, z: 0.0007mm)
* Net: TestNet (width=200nm, material=Tungsten)
*   Connected pins:
*     - Bottom_Pad.anchor
*     - Bottom_Pad.__virtual_Bottom_Pad
*     - Top_Pad.anchor
*     - Top_Pad.__virtual_Top_Pad
*     - Center_Via.__virtual_Center_Via

* ========================================
* COMPONENTS (Schematic-Level Subcircuits)
* ========================================
XBottom_Pad TestNet TestNet Pour(Polysilicon)
XTop_Pad TestNet TestNet Pour(Aluminum)
XCenter_Via TestNet Contact(Tungsten)

* ========================================
* DEVICE EXTRACTION REQUIRES EXPLICIT BINDINGS
* Use 'device: DeviceName.terminal' property
* ========================================

.end
