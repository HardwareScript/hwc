* Hardware Script Native Netlist: ThreePads_Space
* Generated by hwc v0.1.6 (Syntax Unification)
* Format: SPICE3

* ========================================
* NETS
* ========================================
* Net: In (pour: Pad_A, material: Aluminum, z: 0.0000mm)
* Net: Out (pour: Pad_B, material: Aluminum, z: 0.0000mm)
* Net: Mid (pour: Central_Barrier, material: Aluminum, z: 0.0000mm)
* Net: In (width=200nm, material=Tungsten)
*   Connected pins:
*     - Pad_A.__virtual_Pad_A
* Net: Mid (width=200nm, material=Tungsten)
*   Connected pins:
*     - Central_Barrier.__virtual_Central_Barrier
* Net: Out (width=200nm, material=Tungsten)
*   Connected pins:
*     - Pad_B.__virtual_Pad_B

* ========================================
* AUTOMATIC STIMULUS & MODELS
* ========================================
Vgnd GND 0 0
.end
