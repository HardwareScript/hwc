* Hardware Script Native Netlist: Gate_Isolation_Space
* Generated by hwc v0.1.6 (Syntax Unification)
* Format: SPICE3

* ========================================
* NETS
* ========================================
* Net: Out (pour: PMOS_Active, material: Silicon_N, z: 0.0000mm)
* Net: In (pour: Gate_Strip, material: Polysilicon, z: 0.0000mm)
* Net: In (width=200nm, material=Tungsten)
*   Connected pins:
*     - Gate_Strip.__virtual_Gate_Strip
* Net: Out (width=200nm, material=Tungsten)
*   Connected pins:
*     - PMOS_Active.__virtual_PMOS_Active

* ========================================
* AUTOMATIC STIMULUS & MODELS
* ========================================
Vgnd GND 0 0
.end
