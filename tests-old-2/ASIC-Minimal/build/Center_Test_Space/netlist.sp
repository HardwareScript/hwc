* Hardware Script Native Netlist: Center_Test_Space
* Generated by hwc v0.1.6 (Syntax Unification)
* Format: SPICE3

* ========================================
* NETS
* ========================================
* Net: TestNet (pour: Center_Both, material: Aluminum, z: 0.0000mm)
* Net: TestNet (pour: Large_Center, material: Aluminum, z: 0.0000mm)
* Net: TestNet (pour: Corner_BL, material: Aluminum, z: 0.0000mm)
* Net: TestNet (pour: Corner_BR, material: Aluminum, z: 0.0000mm)
* Net: TestNet (pour: Corner_TL, material: Aluminum, z: 0.0000mm)
* Net: TestNet (pour: Corner_TR, material: Aluminum, z: 0.0000mm)
* Net: TestNet (pour: Background, material: Aluminum, z: 0.0000mm)
* Net: TestNet (width=200nm, material=Tungsten)
*   Connected pins:
*     - Center_Both.__virtual_Center_Both
*     - Large_Center.__virtual_Large_Center
*     - Corner_BL.__virtual_Corner_BL
*     - Corner_BR.__virtual_Corner_BR
*     - Corner_TL.__virtual_Corner_TL
*     - Corner_TR.__virtual_Corner_TR
*     - Background.anchor
*     - Background.__virtual_Background

* ========================================
* AUTOMATIC STIMULUS & MODELS
* ========================================
Vgnd GND 0 0
.end
