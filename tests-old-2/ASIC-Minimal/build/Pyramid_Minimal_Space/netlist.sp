* Hardware Script Native Netlist: Pyramid_Minimal_Space
* Generated by hwc v0.1.6 (Syntax Unification)
* Format: SPICE3

* ========================================
* NETS
* ========================================
* Net: TestNet (pour: Base_Left, material: Aluminum, z: 0.0000mm)
* Net: TestNet (pour: Base_Right, material: Aluminum, z: 0.0000mm)
* Net: TestNet (pour: Top_Center, material: Aluminum, z: 0.0000mm)
* Net: TestNet (pour: Background, material: Aluminum, z: 0.0000mm)
* Net: TestNet (width=200nm, material=Tungsten)
*   Connected pins:
*     - Base_Left.__virtual_Base_Left
*     - Base_Right.__virtual_Base_Right
*     - Top_Center.__virtual_Top_Center
*     - Background.anchor
*     - Background.__virtual_Background

* ========================================
* AUTOMATIC STIMULUS & MODELS
* ========================================
Vgnd GND 0 0
.end
