* Hardware Script Native Netlist: Simple_Space
* Generated by hwc v0.1.6 (Syntax Unification)
* Format: SPICE3

* ========================================
* NETS
* ========================================
* Net: A (pour: Pad_A, material: Aluminum, z: 0.0010mm)
* Net: B (pour: Pad_B, material: Aluminum, z: 0.0010mm)
* Net: A (width=180nm, material=Tungsten)
*   Connected pins:
*     - Pad_A.anchor
* Net: B (width=180nm, material=Tungsten)
*   Connected pins:
*     - Pad_B.anchor
*     - Pad_A.anchor
*     - Pad_A.anchor
*     - Pad_B.anchor
*     - Pad_A.anchor
*     - Pad_B.anchor
* Net: TEMP_NET (width=180nm, material=Tungsten)

* ========================================
* AUTOMATIC STIMULUS & MODELS
* ========================================
Vgnd GND 0 0
.end
