* Hardware Script Native Netlist: MinimalTest
* Generated by hwc v0.1.6 (Syntax Unification)
* Format: SPICE3

* ========================================
* NETS
* ========================================
* Net: A (pour: PadA, material: Aluminum, z: 0.0005mm)
* Net: B (pour: PadB, material: Aluminum, z: 0.0005mm)
* Net: A (width=100nm, material=Silicon)
*   Connected pins:
*     - PadA.anchor
* Net: B (width=100nm, material=Silicon)
*   Connected pins:
*     - PadB.anchor
*     - PadA.anchor
*     - PadA.anchor
*     - PadB.anchor
*     - PadA.anchor
*     - PadB.anchor
* Net: TEMP_NET (width=100nm, material=Silicon)

* ========================================
* AUTOMATIC STIMULUS & MODELS
* ========================================
Vgnd GND 0 0
.end
