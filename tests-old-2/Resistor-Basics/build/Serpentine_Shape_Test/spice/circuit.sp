* Hardware Script Pure Circuit (DUT)
* Space: Serpentine_Shape_Test
* Generated by hwc v0.2.1
* Format: SPICE3

* ========================================
* DEVICE EXTRACTION REQUIRES EXPLICIT BINDINGS
* Use 'device: DeviceName.terminal' property
* ========================================

.end
