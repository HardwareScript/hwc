* Hardware Script Transient Waveform Test
* Space: Serpentine_Shape_Test
* Generated by hwc v0.2.1
* Format: SPICE3

.include "circuit.sp"

* ========================================
* STIMULUS & ANALYSIS
* ========================================
.tran 200ns
.end
