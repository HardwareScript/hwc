* Hardware Script DC Operating Point Test
* Space: Variable_Resistor_Space
* Generated by hwc v0.1.6
* Format: SPICE3

* ========================================
* NETS
* ========================================
* Net: In1 (pour: R1_Contact_Left, material: Aluminum, z: 0.0005mm)
* Net: Out1 (pour: R1_Contact_Right, material: Aluminum, z: 0.0005mm)
* Net: In2 (pour: R2_Contact_Left, material: Aluminum, z: 0.0005mm)
* Net: Out2 (pour: R2_Contact_Right, material: Aluminum, z: 0.0005mm)
* Net: In3 (pour: R3_Contact_Left, material: Aluminum, z: 0.0005mm)
* Net: Out3 (pour: R3_Contact_Right, material: Aluminum, z: 0.0005mm)
* Net: In1 (width=300nm, material=Tungsten)
*   Connected pins:
*     - R1_Contact_Left.anchor
*     - R1_Contact_Left.__virtual_R1_Contact_Left
*     - R1_Via_Left.__virtual_R1_Via_Left
* Net: Out1 (width=300nm, material=Tungsten)
*   Connected pins:
*     - R1_Contact_Right.anchor
*     - R1_Contact_Right.__virtual_R1_Contact_Right
*     - R1_Via_Right.__virtual_R1_Via_Right
* Net: In2 (width=300nm, material=Tungsten)
*   Connected pins:
*     - R2_Contact_Left.anchor
*     - R2_Contact_Left.__virtual_R2_Contact_Left
*     - R2_Via_Left.__virtual_R2_Via_Left
* Net: Out2 (width=300nm, material=Tungsten)
*   Connected pins:
*     - R2_Contact_Right.anchor
*     - R2_Contact_Right.__virtual_R2_Contact_Right
*     - R2_Via_Right.__virtual_R2_Via_Right
* Net: In3 (width=300nm, material=Tungsten)
*   Connected pins:
*     - R3_Contact_Left.anchor
*     - R3_Contact_Left.__virtual_R3_Contact_Left
*     - R3_Via_Left.__virtual_R3_Via_Left
* Net: Out3 (width=300nm, material=Tungsten)
*   Connected pins:
*     - R3_Contact_Right.anchor
*     - R3_Contact_Right.__virtual_R3_Contact_Right
*     - R3_Via_Right.__virtual_R3_Via_Right

* ========================================
* EXTRACTED DEVICES
* ========================================
RR2 In2 In2 15000.00
RR3 In3 In3 30000.00
RR1 In1 In1 2000.00

* ========================================
* STIMULUS & ANALYSIS
* ========================================
V_In1 In1 0 DC 1.800
V_In2 In2 0 DC 1.800
V_In3 In3 0 DC 1.800
.op
.end
