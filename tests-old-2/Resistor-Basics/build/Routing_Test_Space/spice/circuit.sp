* Hardware Script Pure Circuit (DUT)
* Space: Routing_Test_Space
* Generated by hwc v0.2.1
* Format: SPICE3

* ========================================
* NETS
* ========================================
* Net: A (pour: Contact_A, material: Aluminum, z: 630nm)
* Net: A (pour: Pad_A, material: Aluminum, z: 630nm)
* Net: B (pour: Contact_B, material: Aluminum, z: 630nm)
* Net: B (pour: Pad_B, material: Aluminum, z: 630nm)
* Net: A (width=300nm, material=Tungsten)
*   Connected pins:
*     - Contact_A.anchor
*     - Contact_A.__virtual_Contact_A
*     - Pad_A.anchor
*     - Pad_A.__virtual_Pad_A
* Net: B (width=300nm, material=Tungsten)
*   Connected pins:
*     - Contact_B.anchor
*     - Contact_B.__virtual_Contact_B
*     - Pad_B.anchor
*     - Pad_B.__virtual_Pad_B

* ========================================
* INTEGRATED TRACE PARASITICS
* ========================================
* Trace resistance
RRtr_B_0 nB_entry B 1.566667e-1
* Ground capacitance
CCgnd_B_0 B GND 1.151044e-16
* Trace resistance
RRtr_A_0 nA_entry A 1.566667e-1
* Ground capacitance
CCgnd_A_0 A GND 1.151044e-16

* Total parasitic elements: 4

.end
