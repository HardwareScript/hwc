* Hardware Script Pure Circuit (DUT)
* Space: Loop_Align_Test_Space
* Generated by hwc v0.2.1
* Format: SPICE3

* ========================================
* DEVICE EXTRACTION REQUIRES EXPLICIT BINDINGS
* Use 'device: DeviceName.terminal' property
* ========================================

.end
