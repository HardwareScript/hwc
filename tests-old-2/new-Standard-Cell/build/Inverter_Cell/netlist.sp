* Hardware Script Native Netlist: Inverter_Cell
* Generated by hwc v0.1.6 (Syntax Unification)
* Format: SPICE3

* ========================================
* NETS
* ========================================
* Net: VDD (pour: PMOS_Inst.VDD_Rail, material: Aluminum, z: 0.0013mm)
* Net: Out (pour: PMOS_Inst.Out_Pad, material: Aluminum, z: 0.0013mm)
* Net: VDD (pour: PMOS_Inst.PMOS_Source, material: Silicon_P, z: 0.0000mm)
* Net: Out (pour: PMOS_Inst.PMOS_Drain, material: Silicon_P, z: 0.0000mm)
* Net: In (pour: PMOS_Inst.Gate_Strip, material: Polysilicon, z: 0.0004mm)
* Net: GND (pour: NMOS_Inst.GND_Rail, material: Aluminum, z: 0.0013mm)
* Net: Out (pour: NMOS_Inst.Out_Pad, material: Aluminum, z: 0.0013mm)
* Net: GND (pour: NMOS_Inst.NMOS_Source, material: Silicon_N, z: 0.0000mm)
* Net: Out (pour: NMOS_Inst.NMOS_Drain, material: Silicon_N, z: 0.0000mm)
* Net: In (pour: NMOS_Inst.Gate_Strip, material: Polysilicon, z: 0.0004mm)
* Net: In (width=200nm, material=Tungsten)
*   Connected pins:
*     - PMOS_Inst.Gate_Strip.anchor
*     - PMOS_Inst.Gate_Strip.__virtual_PMOS_Inst.Gate_Strip
*     - NMOS_Inst.Gate_Strip.anchor
*     - NMOS_Inst.Gate_Strip.__virtual_NMOS_Inst.Gate_Strip
*     - PMOS_Inst.Gate_Strip.__virtual_PMOS_Inst.Gate_Strip
*     - NMOS_Inst.Gate_Strip.__virtual_NMOS_Inst.Gate_Strip
*     - PMOS_Inst.Gate_Strip.__virtual_PMOS_Inst.Gate_Strip
*     - NMOS_Inst.Gate_Strip.__virtual_NMOS_Inst.Gate_Strip
* Net: Out (width=200nm, material=Tungsten)
*   Connected pins:
*     - PMOS_Inst.Out_Pad.anchor
*     - PMOS_Inst.Out_Pad.__virtual_PMOS_Inst.Out_Pad
*     - PMOS_Inst.PMOS_Drain.anchor
*     - PMOS_Inst.PMOS_Drain.__virtual_PMOS_Inst.PMOS_Drain
*     - PMOS_Inst.Via_Drain.__virtual_PMOS_Inst.Via_Drain
*     - NMOS_Inst.Out_Pad.anchor
*     - NMOS_Inst.Out_Pad.__virtual_NMOS_Inst.Out_Pad
*     - NMOS_Inst.NMOS_Drain.anchor
*     - NMOS_Inst.NMOS_Drain.__virtual_NMOS_Inst.NMOS_Drain
*     - NMOS_Inst.Via_Drain.__virtual_NMOS_Inst.Via_Drain
*     - PMOS_Inst.Out_Pad.__virtual_PMOS_Inst.Out_Pad
*     - NMOS_Inst.Out_Pad.__virtual_NMOS_Inst.Out_Pad
*     - PMOS_Inst.Out_Pad.__virtual_PMOS_Inst.Out_Pad
*     - NMOS_Inst.Out_Pad.__virtual_NMOS_Inst.Out_Pad
* Net: VDD (width=200nm, material=Tungsten)
*   Connected pins:
*     - PMOS_Inst.VDD_Rail.anchor
*     - PMOS_Inst.VDD_Rail.__virtual_PMOS_Inst.VDD_Rail
*     - PMOS_Inst.PMOS_Source.anchor
*     - PMOS_Inst.PMOS_Source.__virtual_PMOS_Inst.PMOS_Source
*     - PMOS_Inst.Via_Source.__virtual_PMOS_Inst.Via_Source
* Net: GND (width=200nm, material=Tungsten)
*   Connected pins:
*     - NMOS_Inst.GND_Rail.anchor
*     - NMOS_Inst.GND_Rail.__virtual_NMOS_Inst.GND_Rail
*     - NMOS_Inst.NMOS_Source.anchor
*     - NMOS_Inst.NMOS_Source.__virtual_NMOS_Inst.NMOS_Source
*     - NMOS_Inst.Via_Source.__virtual_NMOS_Inst.Via_Source
* Net: PMOS_Inst.TEMP_NET (width=200nm, material=Tungsten)
* Net: NMOS_Inst.TEMP_NET (width=200nm, material=Tungsten)
* Net: TEMP_NET (width=200nm, material=Tungsten)

* ========================================
* AUTOMATIC STIMULUS & MODELS
* ========================================
Vgnd GND 0 0
.end
