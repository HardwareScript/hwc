* Hardware Script Native Netlist: Center_Alignment_Space
* Generated by hwc v0.1.6 (Syntax Unification)
* Format: SPICE3

* ========================================
* NETS
* ========================================
* Net: SIGNAL (pour: Pad_A, material: Aluminum, z: 0.0000mm)
* Net: SIGNAL (pour: Pad_B, material: Aluminum, z: 0.0000mm)
* Net: SIGNAL (pour: Pad_Center, material: Aluminum, z: 0.0000mm)
* Net: SIGNAL (pour: Pad_Right_Offset, material: Aluminum, z: 0.0000mm)
* Net: SIGNAL (pour: Pad_Gap_Center, material: Aluminum, z: 0.0000mm)
* Net: SIGNAL (pour: Background, material: Aluminum, z: 0.0000mm)
* Net: SIGNAL (width=200nm, material=Tungsten)
*   Connected pins:
*     - Pad_A.__virtual_Pad_A
*     - Pad_B.__virtual_Pad_B
*     - Pad_Center.__virtual_Pad_Center
*     - Pad_Right_Offset.__virtual_Pad_Right_Offset
*     - Pad_Gap_Center.__virtual_Pad_Gap_Center
*     - Background.anchor
*     - Background.__virtual_Background

* ========================================
* AUTOMATIC STIMULUS & MODELS
* ========================================
Vgnd GND 0 0
.end
