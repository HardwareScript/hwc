* Hardware Script Pure Circuit (DUT)
* Space: Parasitic_Extraction_Space
* Generated by hwc v0.2.1
* Format: SPICE3

* ========================================
* NETS
* ========================================
* Net: In (pour: In_Pad, material: Aluminum_Met1, z: 0nm)
* Net: In (pour: Out_Pad, material: Aluminum_Met1, z: 0nm)
* Net: In (pour: Via1_Pad_M1, material: Aluminum_Met1, z: 0nm)
* Net: In (pour: Via1_Pad_M2, material: Aluminum_Met2, z: 720nm)
* Net: In (pour: Via2_Pad_M1, material: Aluminum_Met1, z: 0nm)
* Net: In (pour: Via2_Pad_M2, material: Aluminum_Met2, z: 720nm)
* Net: GND (pour: Dummy_Trace, material: Aluminum_Met1, z: 0nm)
* Net: In (width=500nm, material=Tungsten)
*   Connected pins:
*     - In_Pad.anchor
*     - In_Pad.__virtual_In_Pad
*     - Out_Pad.anchor
*     - Out_Pad.__virtual_Out_Pad
*     - Via1_Pad_M1.anchor
*     - Via1_Pad_M1.__virtual_Via1_Pad_M1
*     - Via1_Pad_M2.anchor
*     - Via1_Pad_M2.__virtual_Via1_Pad_M2
*     - Via_Up.__virtual_Via_Up
*     - Via2_Pad_M1.anchor
*     - Via2_Pad_M1.__virtual_Via2_Pad_M1
*     - Via2_Pad_M2.anchor
*     - Via2_Pad_M2.__virtual_Via2_Pad_M2
*     - Via_Down.__virtual_Via_Down
* Net: GND (width=500nm, material=Tungsten)
*   Connected pins:
*     - Dummy_Trace.anchor
*     - Dummy_Trace.__virtual_Dummy_Trace

* ========================================
* INTEGRATED TRACE PARASITICS
* ========================================
* Trace resistance
RRtr_In_0 nIn_entry In 4.073333e-1
* Trace resistance
RRtr_In_1 In In 1.128000e-1
* Trace resistance
RRtr_In_2 In In 1.128000e-1
* Trace resistance
RRtr_In_3 In In 8.146667e-1
* Ground capacitance
CCgnd_In_3 In GND 2.493930e-16
* Trace resistance
RRtr_In_4 In In 1.128000e-1
* Trace resistance
RRtr_In_5 In In 1.128000e-1
* Trace resistance
RRtr_In_6 In In 4.073333e-1

* Total parasitic elements: 8

.end
