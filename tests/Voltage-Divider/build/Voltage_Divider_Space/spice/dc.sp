* Hardware Script DC Sweep Analysis Test
* Space: Voltage_Divider_Space
* Generated by hwc v0.2.1
* Format: SPICE3

.include "circuit.sp"

* ========================================
* STIMULUS & ANALYSIS
* ========================================
V_In In 0 DC 0.0000e0
V_GND GND 0 DC 0.0000e0
.dc V_In 0.0000e0 1.8000e0 5.0000e-2
.end
