* Hardware Script DC Operating Point Test
* Space: Voltage_Divider_Space
* Generated by hwc v0.3.1
* Format: SPICE3

.include "circuit.sp"

* ========================================
* STIMULUS & ANALYSIS
* ========================================
V_In In 0 DC 1.8000e0
V_GND GND 0 DC 0.0000e0
I_load_Mid Mid 0 DC 1.0000e-6
.op
.end
