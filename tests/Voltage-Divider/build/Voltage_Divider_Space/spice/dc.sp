* Hardware Script DC Operating Point Test
* Space: Voltage_Divider_Space
* Generated by hwc v0.2.1
* Format: SPICE3

.include "circuit.sp"

* ========================================
* STIMULUS & ANALYSIS
* ========================================
V_In In 0 DC 1.800
V_GND GND 0 DC 0.000
.op
.end
