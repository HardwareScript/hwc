* Hardware Script DC Operating Point Test
* Space: Voltage_Divider_Space
* Generated by hwc v0.1.6
* Format: SPICE3

* ========================================
* NETS
* ========================================
* Net: In (pour: R1_Contact_A, material: Aluminum, z: 0.0000mm)
* Net: Mid (pour: R1_Contact_B, material: Aluminum, z: 0.0000mm)
* Net: Mid (pour: R2_Contact_A, material: Aluminum, z: 0.0000mm)
* Net: GND (pour: R2_Contact_B, material: Aluminum, z: 0.0000mm)
* Net: In (pour: In_Pad, material: Aluminum, z: 0.0000mm)
* Net: Mid (pour: Mid_Pad, material: Aluminum, z: 0.0000mm)
* Net: GND (pour: GND_Pad, material: Aluminum, z: 0.0000mm)
* Net: In (width=200nm, material=Tungsten)
*   Connected pins:
*     - R1_Contact_A.anchor
*     - R1_Contact_A.__virtual_R1_Contact_A
*     - Via_R1_A.__virtual_Via_R1_A
*     - In_Pad.anchor
*     - In_Pad.__virtual_In_Pad
*     - In_Pad.__virtual_In_Pad
*     - R1_Contact_A.__virtual_R1_Contact_A
*     - In_Pad.__virtual_In_Pad
*     - R1_Contact_A.__virtual_R1_Contact_A
* Net: Mid (width=200nm, material=Tungsten)
*   Connected pins:
*     - R1_Contact_B.anchor
*     - R1_Contact_B.__virtual_R1_Contact_B
*     - Via_R1_B.__virtual_Via_R1_B
*     - R2_Contact_A.anchor
*     - R2_Contact_A.__virtual_R2_Contact_A
*     - Via_R2_A.__virtual_Via_R2_A
*     - Mid_Pad.anchor
*     - Mid_Pad.__virtual_Mid_Pad
*     - R1_Contact_B.__virtual_R1_Contact_B
*     - Mid_Pad.__virtual_Mid_Pad
*     - Mid_Pad.__virtual_Mid_Pad
*     - R2_Contact_A.__virtual_R2_Contact_A
*     - R1_Contact_B.__virtual_R1_Contact_B
*     - Mid_Pad.__virtual_Mid_Pad
*     - Mid_Pad.__virtual_Mid_Pad
*     - R2_Contact_A.__virtual_R2_Contact_A
* Net: GND (width=200nm, material=Tungsten)
*   Connected pins:
*     - R2_Contact_B.anchor
*     - R2_Contact_B.__virtual_R2_Contact_B
*     - Via_R2_B.__virtual_Via_R2_B
*     - GND_Pad.anchor
*     - GND_Pad.__virtual_GND_Pad
*     - R2_Contact_B.__virtual_R2_Contact_B
*     - GND_Pad.__virtual_GND_Pad
*     - R2_Contact_B.__virtual_R2_Contact_B
*     - GND_Pad.__virtual_GND_Pad
* Net: TEMP_NET (width=200nm, material=Tungsten)

* ========================================
* EXTRACTED DEVICES
* ========================================
RR2 nMid_dev nGND_dev 400.00
RR1 nIn_dev nMid_dev 400.00

* ========================================
* INTEGRATED TRACE PARASITICS
* ========================================
* Trace resistance
RRtr_In_0 nIn_entry nIn_dev 8.460000e0
* Trace resistance
RRtr_Mid_0 nMid_entry nMid_0 9.400000e0
* Ground capacitance
CCgnd_Mid_0 nMid_0 0 1.035940e-17
* Trace resistance
RRtr_Mid_1 nMid_0 nMid_dev 9.400000e0
* Ground capacitance
CCgnd_Mid_1 nMid_dev 0 1.035940e-17
* Trace resistance
RRtr_GND_0 nGND_entry nGND_dev 9.400000e0
* Ground capacitance
CCgnd_GND_0 nGND_dev 0 1.035940e-17

* Total parasitic elements: 7

* ========================================
* STIMULUS & ANALYSIS
* ========================================
V_In nIn_entry 0 DC 1.800
V_GND nGND_entry 0 DC 0.000
.op
.end
