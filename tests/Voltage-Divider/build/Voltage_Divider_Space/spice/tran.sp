* Hardware Script Transient Waveform Test
* Space: Voltage_Divider_Space
* Generated by hwc v0.3.1
* Format: SPICE3

.include "circuit.sp"

* ========================================
* STIMULUS & ANALYSIS
* ========================================
V_In In 0 PULSE(0.0000e0 1.8000e0 0.000e0 1.000e-10 1.000e-10 1.000e-7 2.000e-7)
V_GND GND 0 DC 0.0000e0
I_load_Mid Mid 0 DC 1.0000e-6
.tran 1.000e-11 2.000e-7
.end
