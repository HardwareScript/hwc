* Hardware Script Pure Circuit (DUT)
* Space: Voltage_Divider_Space
* Generated by hwc v0.2.1
* Format: SPICE3

* ========================================
* PDK SUBCIRCUIT: sky130_fd_pr__res_high_po
* ========================================
.subckt sky130_fd_pr__res_high_po A B BULK W=1u L=1u
RR_head A node_1 362
RR_tail node_2 B 362
RR_body node_1 node_2 {3.500000e2 * (L / W)} tc1=-0.00147 tc2=0.0000027 vc1=-0.00032 vc2=0.000018
CC_sub1 A BULK {2.000000e-15 * W * L}
CC_sub2 B BULK {2.000000e-15 * W * L}
.ends sky130_fd_pr__res_high_po

* ========================================
* NETS
* ========================================
* Net: In (pour: R1_Contact_A_LI, material: Titanium_Silicide, z: 580nm)
* Net: Mid (pour: R1_Contact_B_LI, material: Titanium_Silicide, z: 580nm)
* Net: In (pour: R1_Contact_A_Metal, material: Aluminum, z: 830nm)
* Net: Mid (pour: R1_Contact_B_Metal, material: Aluminum, z: 830nm)
* Net: Mid (pour: R2_Contact_A_LI, material: Titanium_Silicide, z: 580nm)
* Net: GND (pour: R2_Contact_B_LI, material: Titanium_Silicide, z: 580nm)
* Net: Mid (pour: R2_Contact_A_Metal, material: Aluminum, z: 830nm)
* Net: GND (pour: R2_Contact_B_Metal, material: Aluminum, z: 830nm)
* Net: In (pour: In_Pad, material: Aluminum, z: 830nm)
* Net: Mid (pour: Mid_Pad, material: Aluminum, z: 830nm)
* Net: GND (pour: GND_Pad, material: Aluminum, z: 830nm)
* Net: GND (pour: GND_Bus, material: Aluminum, z: 830nm)
* Net: GND (pour: R1_Bulk_Tap_Diff, material: P_Plus_Diffusion, z: 0nm)
* Net: GND (pour: R1_Bulk_Tap_LI, material: Titanium_Silicide, z: 580nm)
* Net: GND (pour: R1_Bulk_Tap_Metal, material: Aluminum, z: 830nm)
* Net: GND (pour: R2_Bulk_Tap_Diff, material: P_Plus_Diffusion, z: 0nm)
* Net: GND (pour: R2_Bulk_Tap_LI, material: Titanium_Silicide, z: 580nm)
* Net: GND (pour: R2_Bulk_Tap_Metal, material: Aluminum, z: 830nm)
* Net: In (width=300nm, material=Tungsten)
*   Connected pins:
*     - R1_Contact_A_LI.anchor
*     - R1_Contact_A_LI.__virtual_R1_Contact_A_LI
*     - R1_Via_A_Poly_0.__virtual_R1_Via_A_Poly_0
*     - R1_Via_A_Poly_1.__virtual_R1_Via_A_Poly_1
*     - R1_Via_A_Poly_2.__virtual_R1_Via_A_Poly_2
*     - R1_Contact_A_Metal.anchor
*     - R1_Contact_A_Metal.__virtual_R1_Contact_A_Metal
*     - R1_Via_A_Metal_0.__virtual_R1_Via_A_Metal_0
*     - R1_Via_A_Metal_1.__virtual_R1_Via_A_Metal_1
*     - R1_Via_A_Metal_2.__virtual_R1_Via_A_Metal_2
*     - In_Pad.anchor
*     - In_Pad.__virtual_In_Pad
* Net: Mid (width=300nm, material=Tungsten)
*   Connected pins:
*     - R1_Contact_B_LI.anchor
*     - R1_Contact_B_LI.__virtual_R1_Contact_B_LI
*     - R1_Via_B_Poly_0.__virtual_R1_Via_B_Poly_0
*     - R1_Via_B_Poly_1.__virtual_R1_Via_B_Poly_1
*     - R1_Via_B_Poly_2.__virtual_R1_Via_B_Poly_2
*     - R1_Contact_B_Metal.anchor
*     - R1_Contact_B_Metal.__virtual_R1_Contact_B_Metal
*     - R1_Via_B_Metal_0.__virtual_R1_Via_B_Metal_0
*     - R1_Via_B_Metal_1.__virtual_R1_Via_B_Metal_1
*     - R1_Via_B_Metal_2.__virtual_R1_Via_B_Metal_2
*     - R2_Contact_A_LI.anchor
*     - R2_Contact_A_LI.__virtual_R2_Contact_A_LI
*     - R2_Via_A_Poly_0.__virtual_R2_Via_A_Poly_0
*     - R2_Via_A_Poly_1.__virtual_R2_Via_A_Poly_1
*     - R2_Via_A_Poly_2.__virtual_R2_Via_A_Poly_2
*     - R2_Contact_A_Metal.anchor
*     - R2_Contact_A_Metal.__virtual_R2_Contact_A_Metal
*     - R2_Via_A_Metal_0.__virtual_R2_Via_A_Metal_0
*     - R2_Via_A_Metal_1.__virtual_R2_Via_A_Metal_1
*     - R2_Via_A_Metal_2.__virtual_R2_Via_A_Metal_2
*     - Mid_Pad.anchor
*     - Mid_Pad.__virtual_Mid_Pad
* Net: GND (width=300nm, material=Tungsten)
*   Connected pins:
*     - R2_Contact_B_LI.anchor
*     - R2_Contact_B_LI.__virtual_R2_Contact_B_LI
*     - R2_Via_B_Poly_0.__virtual_R2_Via_B_Poly_0
*     - R2_Via_B_Poly_1.__virtual_R2_Via_B_Poly_1
*     - R2_Via_B_Poly_2.__virtual_R2_Via_B_Poly_2
*     - R2_Contact_B_Metal.anchor
*     - R2_Contact_B_Metal.__virtual_R2_Contact_B_Metal
*     - R2_Via_B_Metal_0.__virtual_R2_Via_B_Metal_0
*     - R2_Via_B_Metal_1.__virtual_R2_Via_B_Metal_1
*     - R2_Via_B_Metal_2.__virtual_R2_Via_B_Metal_2
*     - GND_Pad.anchor
*     - GND_Pad.__virtual_GND_Pad
*     - GND_Bus.anchor
*     - GND_Bus.__virtual_GND_Bus
*     - R1_Bulk_Tap_Diff.anchor
*     - R1_Bulk_Tap_Diff.__virtual_R1_Bulk_Tap_Diff
*     - R1_Bulk_Tap_Contact.__virtual_R1_Bulk_Tap_Contact
*     - R1_Bulk_Tap_LI.anchor
*     - R1_Bulk_Tap_LI.__virtual_R1_Bulk_Tap_LI
*     - R1_Bulk_Tap_Metal.anchor
*     - R1_Bulk_Tap_Metal.__virtual_R1_Bulk_Tap_Metal
*     - R1_Bulk_Tap_Via.__virtual_R1_Bulk_Tap_Via
*     - R2_Bulk_Tap_Diff.anchor
*     - R2_Bulk_Tap_Diff.__virtual_R2_Bulk_Tap_Diff
*     - R2_Bulk_Tap_Contact.__virtual_R2_Bulk_Tap_Contact
*     - R2_Bulk_Tap_LI.anchor
*     - R2_Bulk_Tap_LI.__virtual_R2_Bulk_Tap_LI
*     - R2_Bulk_Tap_Metal.anchor
*     - R2_Bulk_Tap_Metal.__virtual_R2_Bulk_Tap_Metal
*     - R2_Bulk_Tap_Via.__virtual_R2_Bulk_Tap_Via

* ========================================
* EXTRACTED DEVICES
* ========================================
XR2 nMid_li1_1 nGND_li1_2 nGND_pdiff_1 sky130_fd_pr__res_high_po W=1.41u L=4.00u
XR1 nIn_li1 nMid_li1_0 nGND_pdiff_0 sky130_fd_pr__res_high_po W=1.41u L=4.00u

* ========================================
* INTEGRATED TRACE PARASITICS
* ========================================
* Via/Contact resistance
Rvia_In_li1_metal1 nIn_metal1 nIn_li1 1.468558e1
* Via/Contact resistance
Rvia_Mid_li1_metal1_0 nMid_metal1_0 nMid_li1_0 1.468558e1
* Via/Contact resistance
Rvia_Mid_li1_metal1_1 nMid_metal1_1 nMid_li1_1 1.468558e1
* Via/Contact resistance
Rvia_GND_li1_metal1_0 nGND_metal1_0 nGND_li1_0 4.405673e1
* Via/Contact resistance
Rvia_GND_pdiff_li1_0 nGND_li1_0 nGND_pdiff_0 4.405673e1
* Via/Contact resistance
Rvia_GND_li1_metal1_1 nGND_metal1_1 nGND_li1_1 4.405673e1
* Via/Contact resistance
Rvia_GND_pdiff_li1_1 nGND_li1_1 nGND_pdiff_1 4.405673e1
* Via/Contact resistance
Rvia_GND_li1_metal1_2 nGND_metal1_2 nGND_li1_2 1.468558e1
* Trace resistance
Rtr_Mid_0_0 nMid_metal1_0 Mid 2.611111e-1
* Ground capacitance
Cgnd_Mid_0_0 Mid GND 6.906266e-17
* Trace resistance
Rtr_Mid_0_1 Mid nMid_metal1_1 5.222222e-2
* Ground capacitance
Cgnd_Mid_0_1 nMid_metal1_1 GND 1.381253e-17
* Trace resistance
Rtr_GND_1_0 nGND_metal1_2 GND 5.222222e-1
* Trace resistance
Rtr_GND_1_1 GND nGND_metal1_tr1_seg2 2.872222e-1
* Trace resistance
Rtr_GND_1_2 nGND_metal1_tr1_seg2 GND 6.527778e-1
* Trace resistance
Rtr_In_2_0 In nIn_metal1 2.611111e-1
* Ground capacitance
Cgnd_In_2_0 nIn_metal1 GND 6.906266e-17
* Ground capacitance
Cgnd_pour_R1_Contact_A_Metal nIn_metal1 GND 1.298378e-16
* Ground capacitance
Cgnd_pour_R1_Contact_B_Metal nMid_metal1_0 GND 1.298378e-16
* Ground capacitance
Cgnd_pour_R2_Contact_A_Metal nMid_metal1_1 GND 1.298378e-16
* Ground capacitance
Cgnd_pour_In_Pad In GND 2.302089e-16
* Ground capacitance
Cgnd_pour_Mid_Pad Mid GND 2.302089e-16
* Trace resistance
Rbus_GND_Bus_0 nGND_metal1_0 nGND_metal1_1 9.138889e-1
* Trace resistance
Rbus_GND_Bus_to_GND nGND_metal1_1 GND 7.180556e-1

* Total parasitic elements: 24

.end
