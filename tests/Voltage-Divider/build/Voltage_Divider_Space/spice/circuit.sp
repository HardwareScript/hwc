* Hardware Script Pure Circuit (DUT)
* Space: Voltage_Divider_Space
* Generated by hwc v0.3.1
* Format: SPICE3

* ========================================
* FOUNDRY PDK MODEL INCLUDES
* ========================================
.include "sky130_fd_pr/models/sky130_fd_pr__res_high_po.model.spice"

* ========================================
* NETS
* ========================================
* Net: In (pour: sky130_res_high_po, material: Polysilicon, z: 200nm)
* Net: In (pour: sky130_res_high_po, material: P_Plus_Implant_Mask, z: 0nm)
* Net: In (pour: sky130_res_high_po, material: Npc_Mask, z: 380nm)
* Net: Mid (pour: sky130_res_high_po, material: Npc_Mask, z: 380nm)
* Net: In (pour: sky130_res_high_po, material: Titanium_Nitride, z: 580nm)
* Net: In (pour: sky130_res_high_po, material: Aluminum, z: 830nm)
* Net: Mid (pour: sky130_res_high_po, material: Titanium_Nitride, z: 580nm)
* Net: Mid (pour: sky130_res_high_po, material: Aluminum, z: 830nm)
* Net: Mid (pour: sky130_res_high_po, material: Polysilicon, z: 200nm)
* Net: Mid (pour: sky130_res_high_po, material: P_Plus_Implant_Mask, z: 0nm)
* Net: Mid (pour: sky130_res_high_po, material: Npc_Mask, z: 380nm)
* Net: GND (pour: sky130_res_high_po, material: Npc_Mask, z: 380nm)
* Net: Mid (pour: sky130_res_high_po, material: Titanium_Nitride, z: 580nm)
* Net: Mid (pour: sky130_res_high_po, material: Aluminum, z: 830nm)
* Net: GND (pour: sky130_res_high_po, material: Titanium_Nitride, z: 580nm)
* Net: GND (pour: sky130_res_high_po, material: Aluminum, z: 830nm)
* Net: In (pour: pad, material: Aluminum, z: 830nm)
* Net: In (pour: pad, material: Pad_Mask, z: 1.19µm)
* Net: Mid (pour: pad, material: Aluminum, z: 830nm)
* Net: Mid (pour: pad, material: Pad_Mask, z: 1.19µm)
* Net: GND (pour: pad, material: Aluminum, z: 830nm)
* Net: GND (pour: pad, material: Pad_Mask, z: 1.19µm)
* Net: In (width=300nm, material=Aluminum)
*   Connected pins:
*     - sky130_res_high_po.anchor
*     - sky130_res_high_po.__virtual_sky130_res_high_po
*     - sky130_res_high_po.anchor
*     - sky130_res_high_po.__virtual_sky130_res_high_po
*     - sky130_res_high_po.anchor
*     - sky130_res_high_po.__virtual_sky130_res_high_po
*     - sky130_res_high_po.anchor
*     - sky130_res_high_po.__virtual_sky130_res_high_po
*     - sky130_res_high_po.anchor
*     - sky130_res_high_po.__virtual_sky130_res_high_po
*     - pad.anchor
*     - pad.__virtual_pad
*     - pad.anchor
*     - pad.__virtual_pad
*     - .__virtual_
*     - .__virtual_
*     - .__virtual_
*     - .__virtual_
*     - .__virtual_
*     - .__virtual_
*     - .__virtual_
*     - .__virtual_
*     - .__virtual_
* Net: Mid (width=300nm, material=Aluminum)
*   Connected pins:
*     - sky130_res_high_po.anchor
*     - sky130_res_high_po.__virtual_sky130_res_high_po
*     - sky130_res_high_po.anchor
*     - sky130_res_high_po.__virtual_sky130_res_high_po
*     - sky130_res_high_po.anchor
*     - sky130_res_high_po.__virtual_sky130_res_high_po
*     - sky130_res_high_po.anchor
*     - sky130_res_high_po.__virtual_sky130_res_high_po
*     - sky130_res_high_po.anchor
*     - sky130_res_high_po.__virtual_sky130_res_high_po
*     - sky130_res_high_po.anchor
*     - sky130_res_high_po.__virtual_sky130_res_high_po
*     - sky130_res_high_po.anchor
*     - sky130_res_high_po.__virtual_sky130_res_high_po
*     - sky130_res_high_po.anchor
*     - sky130_res_high_po.__virtual_sky130_res_high_po
*     - pad.anchor
*     - pad.__virtual_pad
*     - pad.anchor
*     - pad.__virtual_pad
*     - .__virtual_
*     - .__virtual_
*     - .__virtual_
*     - .__virtual_
*     - .__virtual_
*     - .__virtual_
*     - .__virtual_
*     - .__virtual_
*     - .__virtual_
*     - .__virtual_
*     - .__virtual_
*     - .__virtual_
* Net: GND (width=300nm, material=Aluminum)
*   Connected pins:
*     - sky130_res_high_po.anchor
*     - sky130_res_high_po.__virtual_sky130_res_high_po
*     - sky130_res_high_po.anchor
*     - sky130_res_high_po.__virtual_sky130_res_high_po
*     - sky130_res_high_po.anchor
*     - sky130_res_high_po.__virtual_sky130_res_high_po
*     - pad.anchor
*     - pad.__virtual_pad
*     - pad.anchor
*     - pad.__virtual_pad
*     - .__virtual_
*     - .__virtual_
*     - .__virtual_

* ========================================
* EXTRACTED DEVICES
* ========================================
Xsky130_res_high_po nMid_li1_0 nGND_li1 0 sky130_fd_pr__res_high_po W=1.41u L=3.04u
Xsky130_res_high_po nMid_li1_0 nGND_li1 0 sky130_fd_pr__res_high_po W=1.41u L=3.04u

* ========================================
* INTEGRATED TRACE PARASITICS
* ========================================
* Via/Contact resistance
Rvia_In_li1_metal1_0 nIn_metal1_0 nIn_li1_0 1.153403e1
* Via/Contact resistance
Rvia_Mid_li1_metal1_0 nMid_metal1_0 nMid_li1_0 1.153403e1
* Via/Contact resistance
Rvia_Mid_li1_metal1_1 nMid_metal1_1 nMid_li1_1 1.153403e1
* Via/Contact resistance
Rvia_GND_li1_metal1 nGND_metal1 nGND_li1 1.153403e1
* Trace resistance
Rtr_In_0_0 In nIn_metal1_0 4.543333e-1
* Ground capacitance
Cgnd_In_0_0 nIn_metal1_0 GND 1.201690e-16
* Trace resistance
Rtr_Mid_1_0 nMid_metal1_0 Mid 5.848889e-1
* Ground capacitance
Cgnd_Mid_1_0 Mid GND 1.547004e-16
* Trace resistance
Rtr_Mid_2_0 Mid nMid_metal1_1 5.848889e-1
* Ground capacitance
Cgnd_Mid_2_0 nMid_metal1_1 GND 1.547004e-16
* Trace resistance
Rtr_GND_3_0 nGND_metal1 GND 4.543333e-1
* Ground capacitance
Cgnd_pour_sky130_res_high_po nIn_metal1_0 GND 1.558054e-16
* Ground capacitance
Cgnd_pour_sky130_res_high_po nMid_metal1_0 GND 1.558054e-16
* Ground capacitance
Cgnd_pour_sky130_res_high_po nMid_metal1_1 GND 1.558054e-16
* Ground capacitance
Cgnd_pour_pad In GND 2.302089e-16
* Ground capacitance
Cgnd_pour_pad In GND 8.287520e-17
* Ground capacitance
Cgnd_pour_pad Mid GND 2.302089e-16
* Ground capacitance
Cgnd_pour_pad Mid GND 8.287520e-17

* Total parasitic elements: 18

* ========================================
* NET BRIDGES (STIMULUS TO PHYSICAL TRACES)
* ========================================
V_bridge_Mid Mid nMid_metal1_1 DC 0

.end
