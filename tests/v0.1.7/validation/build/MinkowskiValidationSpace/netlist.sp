* Hardware Script Native Netlist: MinkowskiValidationSpace
* Generated by hwc v0.1.6 (Syntax Unification)
* Format: SPICE3

* ========================================
* NETS
* ========================================

* ========================================
* COMPONENTS
* ========================================
XStart NET_Start_P1_to_End_P1 Connector
XEnd NET_Start_P1_to_End_P1 Connector
XBlock  ObstacleBlock

* ========================================
* DEVICE EXTRACTION REQUIRES EXPLICIT BINDINGS
* Use 'device: DeviceName.terminal' property
* ========================================

.end
