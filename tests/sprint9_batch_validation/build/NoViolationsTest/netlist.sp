* Hardware Script Native Netlist: NoViolationsTest
* Generated by hwc v0.1.6 (Syntax Unification)
* Format: SPICE3

* ========================================
* COMPONENTS
* ========================================
XR1 nc_0 nc_1 Resistor
XR2 nc_2 nc_3 Resistor
XC1 nc_4 nc_5 Capacitor
XC2 nc_6 nc_7 Capacitor
XU1 nc_8 nc_9 nc_10 nc_11 IC

* ========================================
* DEVICE EXTRACTION REQUIRES EXPLICIT BINDINGS
* Use 'device: DeviceName.terminal' property
* ========================================

.end
