* Hardware Script Pure Circuit (DUT)
* Space: CMOS_Inverter_Space
* Generated by hwc v0.2.1
* Format: SPICE3

* ========================================
* PDK SUBCIRCUIT: sky130_fd_pr__pfet_01v8
* ========================================
* Subcircuit 'sky130_fd_pr__pfet_01v8' uses foundry model
.include "sky130_fd_pr/models/sky130_fd_pr__pfet_01v8.model.spice"

* ========================================
* PDK SUBCIRCUIT: sky130_fd_pr__nfet_01v8
* ========================================
* Subcircuit 'sky130_fd_pr__nfet_01v8' uses foundry model
.include "sky130_fd_pr/models/sky130_fd_pr__nfet_01v8.model.spice"

* ========================================
* NETS
* ========================================
* Net: In (pour: PMOS_Inst.PMOS_Gate, material: Polysilicon, z: 150nm)
* Net: In (pour: PMOS_Inst.Gate_Input_Head, material: Polysilicon, z: 150nm)
* Net: In (pour: PMOS_Inst.Gate_Contact_LI, material: Titanium_Nitride, z: 530nm)
* Net: In (pour: PMOS_Inst.Gate_Pad, material: Aluminum, z: 780nm)
* Net: VDD (pour: PMOS_Inst.PMOS_Source_LI, material: Titanium_Nitride, z: 530nm)
* Net: VDD (pour: PMOS_Inst.Source_Pad, material: Aluminum, z: 780nm)
* Net: Out (pour: PMOS_Inst.PMOS_Drain_LI, material: Titanium_Nitride, z: 530nm)
* Net: Out (pour: PMOS_Inst.Out_Pad, material: Aluminum, z: 780nm)
* Net: VDD (pour: PMOS_Inst.Well_Tap_Diff, material: N_Plus_Diffusion, z: 0nm)
* Net: VDD (pour: PMOS_Inst.Well_Tap_LI, material: Titanium_Nitride, z: 530nm)
* Net: VDD (pour: PMOS_Inst.Well_Tap_M1, material: Aluminum, z: 780nm)
* Net: In (pour: NMOS_Inst.NMOS_Gate, material: Polysilicon, z: 150nm)
* Net: In (pour: NMOS_Inst.Gate_Input_Head, material: Polysilicon, z: 150nm)
* Net: In (pour: NMOS_Inst.Gate_Contact_LI, material: Titanium_Nitride, z: 530nm)
* Net: In (pour: NMOS_Inst.Gate_Pad, material: Aluminum, z: 780nm)
* Net: VSS (pour: NMOS_Inst.NMOS_Source_LI, material: Titanium_Nitride, z: 530nm)
* Net: VSS (pour: NMOS_Inst.Source_Pad, material: Aluminum, z: 780nm)
* Net: Out (pour: NMOS_Inst.NMOS_Drain_LI, material: Titanium_Nitride, z: 530nm)
* Net: Out (pour: NMOS_Inst.Out_Pad, material: Aluminum, z: 780nm)
* Net: VSS (pour: NMOS_Inst.Sub_Tap_Diff, material: P_Plus_Diffusion, z: 0nm)
* Net: VSS (pour: NMOS_Inst.Sub_Tap_LI, material: Titanium_Nitride, z: 530nm)
* Net: VSS (pour: NMOS_Inst.Sub_Tap_M1, material: Aluminum, z: 780nm)
* Net: VDD (pour: VDD_Pad, material: Aluminum, z: 780nm)
* Net: VSS (pour: VSS_Pad, material: Aluminum, z: 780nm)
* Net: In (pour: Input_Pad, material: Aluminum, z: 780nm)
* Net: Out (pour: Output_Pad, material: Aluminum, z: 780nm)
* Net: VDD (width=140nm, material=Tungsten)
*   Connected pins:
*     - PMOS_Inst.PMOS_Source_LI.anchor
*     - PMOS_Inst.PMOS_Source_LI.__virtual_PMOS_Inst.PMOS_Source_LI
*     - PMOS_Inst.Source_Pad.anchor
*     - PMOS_Inst.Source_Pad.__virtual_PMOS_Inst.Source_Pad
*     - PMOS_Inst.PMOS_S_Via_Diff_0.__virtual_PMOS_Inst.PMOS_S_Via_Diff_0
*     - PMOS_Inst.PMOS_S_Via_M1_0.__virtual_PMOS_Inst.PMOS_S_Via_M1_0
*     - PMOS_Inst.PMOS_S_Via_Diff_1.__virtual_PMOS_Inst.PMOS_S_Via_Diff_1
*     - PMOS_Inst.PMOS_S_Via_M1_1.__virtual_PMOS_Inst.PMOS_S_Via_M1_1
*     - PMOS_Inst.PMOS_S_Via_Diff_2.__virtual_PMOS_Inst.PMOS_S_Via_Diff_2
*     - PMOS_Inst.PMOS_S_Via_M1_2.__virtual_PMOS_Inst.PMOS_S_Via_M1_2
*     - PMOS_Inst.Well_Tap_Diff.anchor
*     - PMOS_Inst.Well_Tap_Diff.__virtual_PMOS_Inst.Well_Tap_Diff
*     - PMOS_Inst.Well_Tap_LI.anchor
*     - PMOS_Inst.Well_Tap_LI.__virtual_PMOS_Inst.Well_Tap_LI
*     - PMOS_Inst.Well_Tap_M1.anchor
*     - PMOS_Inst.Well_Tap_M1.__virtual_PMOS_Inst.Well_Tap_M1
*     - PMOS_Inst.Well_Tap_Licon.__virtual_PMOS_Inst.Well_Tap_Licon
*     - PMOS_Inst.Well_Tap_Mcon.__virtual_PMOS_Inst.Well_Tap_Mcon
*     - VDD_Pad.anchor
*     - VDD_Pad.__virtual_VDD_Pad
* Net: VSS (width=140nm, material=Tungsten)
*   Connected pins:
*     - NMOS_Inst.NMOS_Source_LI.anchor
*     - NMOS_Inst.NMOS_Source_LI.__virtual_NMOS_Inst.NMOS_Source_LI
*     - NMOS_Inst.Source_Pad.anchor
*     - NMOS_Inst.Source_Pad.__virtual_NMOS_Inst.Source_Pad
*     - NMOS_Inst.NMOS_S_Via_Diff_0.__virtual_NMOS_Inst.NMOS_S_Via_Diff_0
*     - NMOS_Inst.NMOS_S_Via_M1_0.__virtual_NMOS_Inst.NMOS_S_Via_M1_0
*     - NMOS_Inst.NMOS_S_Via_Diff_1.__virtual_NMOS_Inst.NMOS_S_Via_Diff_1
*     - NMOS_Inst.NMOS_S_Via_M1_1.__virtual_NMOS_Inst.NMOS_S_Via_M1_1
*     - NMOS_Inst.Sub_Tap_Diff.anchor
*     - NMOS_Inst.Sub_Tap_Diff.__virtual_NMOS_Inst.Sub_Tap_Diff
*     - NMOS_Inst.Sub_Tap_LI.anchor
*     - NMOS_Inst.Sub_Tap_LI.__virtual_NMOS_Inst.Sub_Tap_LI
*     - NMOS_Inst.Sub_Tap_M1.anchor
*     - NMOS_Inst.Sub_Tap_M1.__virtual_NMOS_Inst.Sub_Tap_M1
*     - NMOS_Inst.Sub_Tap_Licon.__virtual_NMOS_Inst.Sub_Tap_Licon
*     - NMOS_Inst.Sub_Tap_Mcon.__virtual_NMOS_Inst.Sub_Tap_Mcon
*     - VSS_Pad.anchor
*     - VSS_Pad.__virtual_VSS_Pad
* Net: In (width=140nm, material=Tungsten)
*   Connected pins:
*     - PMOS_Inst.PMOS_Gate.anchor
*     - PMOS_Inst.PMOS_Gate.__virtual_PMOS_Inst.PMOS_Gate
*     - PMOS_Inst.Gate_Input_Head.anchor
*     - PMOS_Inst.Gate_Input_Head.__virtual_PMOS_Inst.Gate_Input_Head
*     - PMOS_Inst.Gate_Contact_LI.anchor
*     - PMOS_Inst.Gate_Contact_LI.__virtual_PMOS_Inst.Gate_Contact_LI
*     - PMOS_Inst.Gate_Pad.anchor
*     - PMOS_Inst.Gate_Pad.__virtual_PMOS_Inst.Gate_Pad
*     - PMOS_Inst.Gate_Via_Poly_LI.__virtual_PMOS_Inst.Gate_Via_Poly_LI
*     - PMOS_Inst.Gate_Via_LI_M1.__virtual_PMOS_Inst.Gate_Via_LI_M1
*     - NMOS_Inst.NMOS_Gate.anchor
*     - NMOS_Inst.NMOS_Gate.__virtual_NMOS_Inst.NMOS_Gate
*     - NMOS_Inst.Gate_Input_Head.anchor
*     - NMOS_Inst.Gate_Input_Head.__virtual_NMOS_Inst.Gate_Input_Head
*     - NMOS_Inst.Gate_Contact_LI.anchor
*     - NMOS_Inst.Gate_Contact_LI.__virtual_NMOS_Inst.Gate_Contact_LI
*     - NMOS_Inst.Gate_Pad.anchor
*     - NMOS_Inst.Gate_Pad.__virtual_NMOS_Inst.Gate_Pad
*     - NMOS_Inst.Gate_Via_Poly_LI.__virtual_NMOS_Inst.Gate_Via_Poly_LI
*     - NMOS_Inst.Gate_Via_LI_M1.__virtual_NMOS_Inst.Gate_Via_LI_M1
*     - Input_Pad.anchor
*     - Input_Pad.__virtual_Input_Pad
* Net: Out (width=140nm, material=Tungsten)
*   Connected pins:
*     - PMOS_Inst.PMOS_Drain_LI.anchor
*     - PMOS_Inst.PMOS_Drain_LI.__virtual_PMOS_Inst.PMOS_Drain_LI
*     - PMOS_Inst.Out_Pad.anchor
*     - PMOS_Inst.Out_Pad.__virtual_PMOS_Inst.Out_Pad
*     - PMOS_Inst.PMOS_D_Via_Diff_0.__virtual_PMOS_Inst.PMOS_D_Via_Diff_0
*     - PMOS_Inst.PMOS_D_Via_M1_0.__virtual_PMOS_Inst.PMOS_D_Via_M1_0
*     - PMOS_Inst.PMOS_D_Via_Diff_1.__virtual_PMOS_Inst.PMOS_D_Via_Diff_1
*     - PMOS_Inst.PMOS_D_Via_M1_1.__virtual_PMOS_Inst.PMOS_D_Via_M1_1
*     - PMOS_Inst.PMOS_D_Via_Diff_2.__virtual_PMOS_Inst.PMOS_D_Via_Diff_2
*     - PMOS_Inst.PMOS_D_Via_M1_2.__virtual_PMOS_Inst.PMOS_D_Via_M1_2
*     - NMOS_Inst.NMOS_Drain_LI.anchor
*     - NMOS_Inst.NMOS_Drain_LI.__virtual_NMOS_Inst.NMOS_Drain_LI
*     - NMOS_Inst.Out_Pad.anchor
*     - NMOS_Inst.Out_Pad.__virtual_NMOS_Inst.Out_Pad
*     - NMOS_Inst.NMOS_D_Via_Diff_0.__virtual_NMOS_Inst.NMOS_D_Via_Diff_0
*     - NMOS_Inst.NMOS_D_Via_M1_0.__virtual_NMOS_Inst.NMOS_D_Via_M1_0
*     - NMOS_Inst.NMOS_D_Via_Diff_1.__virtual_NMOS_Inst.NMOS_D_Via_Diff_1
*     - NMOS_Inst.NMOS_D_Via_M1_1.__virtual_NMOS_Inst.NMOS_D_Via_M1_1
*     - Output_Pad.anchor
*     - Output_Pad.__virtual_Output_Pad

* ========================================
* EXTRACTED DEVICES
* ========================================
XPMOS_Inst.M_PMOS nOut_diff_1 nIn_poly_1 nVDD_diff nVDD_diff sky130_fd_pr__pfet_01v8 W=2.00u L=0.15u AD=1.70p AS=1.70p PD=5.70u PS=5.70u NRD=0.42 NRS=0.42 SA=0.85u SB=0.85u
XNMOS_Inst.M_NMOS nOut_diff_0 nIn_poly_0 nVSS_diff nVSS_diff sky130_fd_pr__nfet_01v8 W=1.00u L=0.15u AD=0.85p AS=0.85p PD=3.70u PS=3.70u NRD=0.85 NRS=0.85 SA=0.85u SB=0.85u

* ========================================
* INTEGRATED TRACE PARASITICS
* ========================================
* Via/Contact resistance
Rvia_VDD_diff_li1 nVDD_li1 nVDD_diff 3.998148e1
* Via/Contact resistance
Rvia_VDD_li1_metal1 nVDD_metal1 nVDD_li1 5.000439e0
* Via/Contact resistance
Rvia_VSS_diff_li1 nVSS_li1 nVSS_diff 5.330865e1
* Via/Contact resistance
Rvia_VSS_li1_metal1 nVSS_metal1 nVSS_li1 6.667252e0
* Via/Contact resistance
Rvia_In_poly_li1_0 nIn_li1_0 nIn_poly_0 1.000088e2
* Via/Contact resistance
Rvia_In_li1_metal1_0 nIn_metal1_0 nIn_li1_0 2.000176e1
* Via/Contact resistance
Rvia_In_poly_li1_1 nIn_li1_1 nIn_poly_1 1.000088e2
* Via/Contact resistance
Rvia_In_li1_metal1_1 nIn_metal1_1 nIn_li1_1 2.000176e1
* Via/Contact resistance
Rvia_Out_diff_li1_0 nOut_li1_0 nOut_diff_0 7.996297e1
* Via/Contact resistance
Rvia_Out_li1_metal1_0 nOut_metal1_0 nOut_li1_0 1.000088e1
* Via/Contact resistance
Rvia_Out_diff_li1_1 nOut_li1_1 nOut_diff_1 5.330865e1
* Via/Contact resistance
Rvia_Out_li1_metal1_1 nOut_metal1_1 nOut_li1_1 6.667252e0
* Trace resistance
Rtr_In_0_0 nIn_metal1_1 nIn_metal1_0 2.389167e0
* Ground capacitance
Cgnd_In_0_0 nIn_metal1_0 VSS 2.808548e-16
* Trace resistance
Rtr_In_0_1 nIn_metal1_0 nIn_metal1_tr0_seg2 1.151500e0
* Ground capacitance
Cgnd_In_0_1 nIn_metal1_tr0_seg2 VSS 1.353628e-16
* Trace resistance
Rtr_In_0_2 nIn_metal1_tr0_seg2 nIn_metal1_tr0_seg3 1.163191e-1
* Ground capacitance
Cgnd_In_0_2 nIn_metal1_tr0_seg3 VSS 1.367371e-17
* Trace resistance
Rtr_In_0_3 nIn_metal1_tr0_seg3 nIn_metal1_1 8.773333e-1
* Ground capacitance
Cgnd_In_0_3 nIn_metal1_1 VSS 1.031336e-16
* Trace resistance
Rtr_VDD_1_0 VDD nVDD_metal1_tr1_seg1 3.431000e-1
* Ground capacitance
Cgnd_VDD_1_0 nVDD_metal1_tr1_seg1 VSS 2.520787e-16
* Trace resistance
Rtr_VDD_1_1 nVDD_metal1_tr1_seg1 nVDD_metal1 4.652763e-2
* Ground capacitance
Cgnd_VDD_1_1 nVDD_metal1 VSS 3.418428e-17
* Ground capacitance
Cgnd_VDD_1_2 nVDD_metal1 VSS 2.635892e-16
* Trace resistance
Rtr_Out_2_0 nOut_metal1_1 nOut_metal1_0 2.780833e0
* Ground capacitance
Cgnd_Out_2_0 nOut_metal1_0 VSS 3.268966e-16
* Trace resistance
Rtr_Out_2_1 nOut_metal1_0 nOut_metal1_tr2_seg2 1.151500e0
* Ground capacitance
Cgnd_Out_2_1 nOut_metal1_tr2_seg2 VSS 1.353628e-16
* Trace resistance
Rtr_Out_2_2 nOut_metal1_tr2_seg2 nOut_metal1_tr2_seg3 1.163191e-1
* Ground capacitance
Cgnd_Out_2_2 nOut_metal1_tr2_seg3 VSS 1.367371e-17
* Trace resistance
Rtr_Out_2_3 nOut_metal1_tr2_seg3 Out 9.752500e-1
* Ground capacitance
Cgnd_Out_2_3 Out VSS 1.146440e-16
* Trace resistance
Rtr_VSS_3_0 VSS nVSS_metal1 3.431000e-1
* Ground capacitance
Cgnd_VDD_5_0 nVDD_metal1 VSS 2.071880e-17
* Lateral coupling capacitance
Cc_In_Out_0_7 nIn_metal1_tr0_seg1 nOut_metal1_tr2_seg1 3.580899e-16
* Lateral coupling capacitance
Cc_In_Out_3_7 nIn_metal1_1 nOut_metal1_tr2_seg1 1.314953e-16
* Ground capacitance
Cgnd_pour_PMOS_Inst.Gate_Contact_LI nIn_li1_1 VSS 1.553910e-17
* Ground capacitance
Cgnd_pour_PMOS_Inst.Gate_Pad nIn_metal1_1 VSS 2.071880e-17
* Ground capacitance
Cgnd_pour_PMOS_Inst.Source_Pad nVDD_metal1 VSS 1.381253e-16
* Ground capacitance
Cgnd_pour_PMOS_Inst.Out_Pad nOut_metal1_1 VSS 1.381253e-16
* Ground capacitance
Cgnd_pour_PMOS_Inst.Well_Tap_LI nVDD_li1 VSS 1.553910e-17
* Trace resistance
Rpour_PMOS_Inst.Well_Tap_LI nVDD_li1 nVDD_li1_strap 4.500000e1
* Ground capacitance
Cgnd_pour_PMOS_Inst.Well_Tap_M1 nVDD_metal1 VSS 2.071880e-17
* Trace resistance
Rpour_PMOS_Inst.Well_Tap_M1 nVDD_metal1 nVDD_metal1_strap 7.833333e-2
* Ground capacitance
Cgnd_pour_NMOS_Inst.Gate_Contact_LI nIn_li1_0 VSS 1.553910e-17
* Ground capacitance
Cgnd_pour_NMOS_Inst.Gate_Pad nIn_metal1_0 VSS 2.071880e-17
* Ground capacitance
Cgnd_pour_NMOS_Inst.Out_Pad nOut_metal1_0 VSS 6.906266e-17
* Trace resistance
Rpour_NMOS_Inst.Sub_Tap_LI nVSS_li1 nVSS_li1_strap 4.500000e1
* Trace resistance
Rpour_NMOS_Inst.Sub_Tap_M1 nVSS_metal1 nVSS_metal1_strap 7.833333e-2
* Ground capacitance
Cgnd_pour_VDD_Pad VDD VSS 3.315008e-16
* Ground capacitance
Cgnd_pour_Input_Pad In VSS 3.315008e-16
* Ground capacitance
Cgnd_pour_Output_Pad Out VSS 3.315008e-16

* Total parasitic elements: 53

.end
