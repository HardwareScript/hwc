* Hardware Script Native Netlist: VoxelSyncTest
* Generated by hwc v0.1.6 (Syntax Unification)
* Format: SPICE3

* ========================================
* NETS
* ========================================
* Net: TestNet (pour: CopperTrace, material: TestCopper, layer: 11)
* Net: TestNet (width=100000nm, material=TestCopper)
*   Connected pins:
*     - CopperTrace.anchor

* ========================================
* COMPONENTS
* ========================================
XCopperTrace TestNet Pour(TestCopper)

* ========================================
* DEVICE EXTRACTION REQUIRES EXPLICIT BINDINGS
* Use 'device: DeviceName.terminal' property
* ========================================

.end
