* Hardware Script Native Netlist: Strategy_Router_Test
* Generated by hwc v0.1.6 (Syntax Unification)
* Format: SPICE3

* ========================================
* NETS
* ========================================
* Net: DDR5_BUS (pour: D0[0]_Pad_Copper, material: Copper, z: 0.0000mm)
* Net: DDR5_BUS (pour: D0[1]_Pad_Copper, material: Copper, z: 0.0000mm)
* Net: DDR5_BUS (pour: D0[2]_Pad_Copper, material: Copper, z: 0.0000mm)
* Net: PCIE_BUS (pour: P0[0]_Pad_Copper, material: Copper, z: 0.0000mm)
* Net: PCIE_BUS (pour: P0[1]_Pad_Copper, material: Copper, z: 0.0000mm)
* Net: PCIE_BUS (pour: P0[2]_Pad_Copper, material: Copper, z: 0.0000mm)
* Net: USB_BUS (pour: U0[0]_Pad_Copper, material: Copper, z: 0.0000mm)
* Net: USB_BUS (pour: U0[1]_Pad_Copper, material: Copper, z: 0.0000mm)
* Net: USB_BUS (pour: U0[2]_Pad_Copper, material: Copper, z: 0.0000mm)
* Net: RELAXED_BUS (pour: R0[0]_Pad_Copper, material: Copper, z: 0.0000mm)
* Net: RELAXED_BUS (pour: R0[1]_Pad_Copper, material: Copper, z: 0.0000mm)
* Net: RELAXED_BUS (pour: R0[2]_Pad_Copper, material: Copper, z: 0.0000mm)
* Net: DDR5_BUS (width=200000nm, material=FR4)
* Net: PCIE_BUS (width=200000nm, material=FR4)
* Net: USB_BUS (width=200000nm, material=FR4)
* Net: RELAXED_BUS (width=200000nm, material=FR4)

* ========================================
* COMPONENTS
* ========================================
XD0[0] DDR5_BUS Pad
XD0[0]_Pad_Copper DDR5_BUS Pour(Copper)
XD0[1] DDR5_BUS Pad
XD0[1]_Pad_Copper DDR5_BUS Pour(Copper)
XD0[2] DDR5_BUS Pad
XD0[2]_Pad_Copper DDR5_BUS Pour(Copper)
XP0[0] PCIE_BUS Pad
XP0[0]_Pad_Copper PCIE_BUS Pour(Copper)
XP0[1] PCIE_BUS Pad
XP0[1]_Pad_Copper PCIE_BUS Pour(Copper)
XP0[2] PCIE_BUS Pad
XP0[2]_Pad_Copper PCIE_BUS Pour(Copper)
XU0[0] USB_BUS Pad
XU0[0]_Pad_Copper USB_BUS Pour(Copper)
XU0[1] USB_BUS Pad
XU0[1]_Pad_Copper USB_BUS Pour(Copper)
XU0[2] USB_BUS Pad
XU0[2]_Pad_Copper USB_BUS Pour(Copper)
XR0[0] RELAXED_BUS Pad
XR0[0]_Pad_Copper RELAXED_BUS Pour(Copper)
XR0[1] RELAXED_BUS Pad
XR0[1]_Pad_Copper RELAXED_BUS Pour(Copper)
XR0[2] RELAXED_BUS Pad
XR0[2]_Pad_Copper RELAXED_BUS Pour(Copper)

* ========================================
* DEVICE EXTRACTION REQUIRES EXPLICIT BINDINGS
* Use 'device: DeviceName.terminal' property
* ========================================

.end
