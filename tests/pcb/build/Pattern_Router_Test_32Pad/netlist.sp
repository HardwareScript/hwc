* Hardware Script Native Netlist: Pattern_Router_Test_32Pad
* Generated by hwc v0.1.6 (Syntax Unification)
* Format: SPICE3

* ========================================
* NETS
* ========================================
* Net: ALL_PADS (pour: R0[0]_Pad_Copper, material: Copper, z: 0.0000mm)
* Net: ALL_PADS (pour: R0[1]_Pad_Copper, material: Copper, z: 0.0000mm)
* Net: ALL_PADS (pour: R0[2]_Pad_Copper, material: Copper, z: 0.0000mm)
* Net: ALL_PADS (pour: R0[3]_Pad_Copper, material: Copper, z: 0.0000mm)
* Net: ALL_PADS (pour: R0[4]_Pad_Copper, material: Copper, z: 0.0000mm)
* Net: ALL_PADS (pour: R0[5]_Pad_Copper, material: Copper, z: 0.0000mm)
* Net: ALL_PADS (pour: R0[6]_Pad_Copper, material: Copper, z: 0.0000mm)
* Net: ALL_PADS (pour: R0[7]_Pad_Copper, material: Copper, z: 0.0000mm)
* Net: ALL_PADS (pour: R1[0]_Pad_Copper, material: Copper, z: 0.0000mm)
* Net: ALL_PADS (pour: R1[1]_Pad_Copper, material: Copper, z: 0.0000mm)
* Net: ALL_PADS (pour: R1[2]_Pad_Copper, material: Copper, z: 0.0000mm)
* Net: ALL_PADS (pour: R1[3]_Pad_Copper, material: Copper, z: 0.0000mm)
* Net: ALL_PADS (pour: R1[4]_Pad_Copper, material: Copper, z: 0.0000mm)
* Net: ALL_PADS (pour: R1[5]_Pad_Copper, material: Copper, z: 0.0000mm)
* Net: ALL_PADS (pour: R1[6]_Pad_Copper, material: Copper, z: 0.0000mm)
* Net: ALL_PADS (pour: R1[7]_Pad_Copper, material: Copper, z: 0.0000mm)
* Net: ALL_PADS (pour: R2[0]_Pad_Copper, material: Copper, z: 0.0000mm)
* Net: ALL_PADS (pour: R2[1]_Pad_Copper, material: Copper, z: 0.0000mm)
* Net: ALL_PADS (pour: R2[2]_Pad_Copper, material: Copper, z: 0.0000mm)
* Net: ALL_PADS (pour: R2[3]_Pad_Copper, material: Copper, z: 0.0000mm)
* Net: ALL_PADS (pour: R2[4]_Pad_Copper, material: Copper, z: 0.0000mm)
* Net: ALL_PADS (pour: R2[5]_Pad_Copper, material: Copper, z: 0.0000mm)
* Net: ALL_PADS (pour: R2[6]_Pad_Copper, material: Copper, z: 0.0000mm)
* Net: ALL_PADS (pour: R2[7]_Pad_Copper, material: Copper, z: 0.0000mm)
* Net: ALL_PADS (pour: R3[0]_Pad_Copper, material: Copper, z: 0.0000mm)
* Net: ALL_PADS (pour: R3[1]_Pad_Copper, material: Copper, z: 0.0000mm)
* Net: ALL_PADS (pour: R3[2]_Pad_Copper, material: Copper, z: 0.0000mm)
* Net: ALL_PADS (pour: R3[3]_Pad_Copper, material: Copper, z: 0.0000mm)
* Net: ALL_PADS (pour: R3[4]_Pad_Copper, material: Copper, z: 0.0000mm)
* Net: ALL_PADS (pour: R3[5]_Pad_Copper, material: Copper, z: 0.0000mm)
* Net: ALL_PADS (pour: R3[6]_Pad_Copper, material: Copper, z: 0.0000mm)
* Net: ALL_PADS (pour: R3[7]_Pad_Copper, material: Copper, z: 0.0000mm)
* Net: ALL_PADS (width=200000nm, material=FR4)

* ========================================
* COMPONENTS
* ========================================
XR0[0] ALL_PADS Pad
XR0[0]_Pad_Copper ALL_PADS Pour(Copper)
XR0[1] ALL_PADS Pad
XR0[1]_Pad_Copper ALL_PADS Pour(Copper)
XR0[2] ALL_PADS Pad
XR0[2]_Pad_Copper ALL_PADS Pour(Copper)
XR0[3] ALL_PADS Pad
XR0[3]_Pad_Copper ALL_PADS Pour(Copper)
XR0[4] ALL_PADS Pad
XR0[4]_Pad_Copper ALL_PADS Pour(Copper)
XR0[5] ALL_PADS Pad
XR0[5]_Pad_Copper ALL_PADS Pour(Copper)
XR0[6] ALL_PADS Pad
XR0[6]_Pad_Copper ALL_PADS Pour(Copper)
XR0[7] ALL_PADS Pad
XR0[7]_Pad_Copper ALL_PADS Pour(Copper)
XR1[0] ALL_PADS Pad
XR1[0]_Pad_Copper ALL_PADS Pour(Copper)
XR1[1] ALL_PADS Pad
XR1[1]_Pad_Copper ALL_PADS Pour(Copper)
XR1[2] ALL_PADS Pad
XR1[2]_Pad_Copper ALL_PADS Pour(Copper)
XR1[3] ALL_PADS Pad
XR1[3]_Pad_Copper ALL_PADS Pour(Copper)
XR1[4] ALL_PADS Pad
XR1[4]_Pad_Copper ALL_PADS Pour(Copper)
XR1[5] ALL_PADS Pad
XR1[5]_Pad_Copper ALL_PADS Pour(Copper)
XR1[6] ALL_PADS Pad
XR1[6]_Pad_Copper ALL_PADS Pour(Copper)
XR1[7] ALL_PADS Pad
XR1[7]_Pad_Copper ALL_PADS Pour(Copper)
XR2[0] ALL_PADS Pad
XR2[0]_Pad_Copper ALL_PADS Pour(Copper)
XR2[1] ALL_PADS Pad
XR2[1]_Pad_Copper ALL_PADS Pour(Copper)
XR2[2] ALL_PADS Pad
XR2[2]_Pad_Copper ALL_PADS Pour(Copper)
XR2[3] ALL_PADS Pad
XR2[3]_Pad_Copper ALL_PADS Pour(Copper)
XR2[4] ALL_PADS Pad
XR2[4]_Pad_Copper ALL_PADS Pour(Copper)
XR2[5] ALL_PADS Pad
XR2[5]_Pad_Copper ALL_PADS Pour(Copper)
XR2[6] ALL_PADS Pad
XR2[6]_Pad_Copper ALL_PADS Pour(Copper)
XR2[7] ALL_PADS Pad
XR2[7]_Pad_Copper ALL_PADS Pour(Copper)
XR3[0] ALL_PADS Pad
XR3[0]_Pad_Copper ALL_PADS Pour(Copper)
XR3[1] ALL_PADS Pad
XR3[1]_Pad_Copper ALL_PADS Pour(Copper)
XR3[2] ALL_PADS Pad
XR3[2]_Pad_Copper ALL_PADS Pour(Copper)
XR3[3] ALL_PADS Pad
XR3[3]_Pad_Copper ALL_PADS Pour(Copper)
XR3[4] ALL_PADS Pad
XR3[4]_Pad_Copper ALL_PADS Pour(Copper)
XR3[5] ALL_PADS Pad
XR3[5]_Pad_Copper ALL_PADS Pour(Copper)
XR3[6] ALL_PADS Pad
XR3[6]_Pad_Copper ALL_PADS Pour(Copper)
XR3[7] ALL_PADS Pad
XR3[7]_Pad_Copper ALL_PADS Pour(Copper)

* ========================================
* DEVICE EXTRACTION REQUIRES EXPLICIT BINDINGS
* Use 'device: DeviceName.terminal' property
* ========================================

.end
