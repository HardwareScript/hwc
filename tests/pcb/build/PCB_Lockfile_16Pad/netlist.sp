* Hardware Script Native Netlist: PCB_Lockfile_16Pad
* Generated by hwc v0.1.6 (Syntax Unification)
* Format: SPICE3

* ========================================
* NETS
* ========================================
* Net: ALL_PADS (pour: J0[0]_Pad_Copper, material: Copper, z: 0.0000mm)
* Net: ALL_PADS (pour: J0[1]_Pad_Copper, material: Copper, z: 0.0000mm)
* Net: ALL_PADS (pour: J0[2]_Pad_Copper, material: Copper, z: 0.0000mm)
* Net: ALL_PADS (pour: J0[3]_Pad_Copper, material: Copper, z: 0.0000mm)
* Net: ALL_PADS (pour: J1[0]_Pad_Copper, material: Copper, z: 0.0000mm)
* Net: ALL_PADS (pour: J1[1]_Pad_Copper, material: Copper, z: 0.0000mm)
* Net: ALL_PADS (pour: J1[2]_Pad_Copper, material: Copper, z: 0.0000mm)
* Net: ALL_PADS (pour: J1[3]_Pad_Copper, material: Copper, z: 0.0000mm)
* Net: ALL_PADS (pour: J2[0]_Pad_Copper, material: Copper, z: 0.0000mm)
* Net: ALL_PADS (pour: J2[1]_Pad_Copper, material: Copper, z: 0.0000mm)
* Net: ALL_PADS (pour: J2[2]_Pad_Copper, material: Copper, z: 0.0000mm)
* Net: ALL_PADS (pour: J2[3]_Pad_Copper, material: Copper, z: 0.0000mm)
* Net: ALL_PADS (pour: J3[0]_Pad_Copper, material: Copper, z: 0.0000mm)
* Net: ALL_PADS (pour: J3[1]_Pad_Copper, material: Copper, z: 0.0000mm)
* Net: ALL_PADS (pour: J3[2]_Pad_Copper, material: Copper, z: 0.0000mm)
* Net: ALL_PADS (pour: J3[3]_Pad_Copper, material: Copper, z: 0.0000mm)
* Net: ALL_PADS (width=200000nm, material=FR4)

* ========================================
* COMPONENTS
* ========================================
XJ0[0] ALL_PADS Pad
XJ0[0]_Pad_Copper ALL_PADS Pour(Copper)
XJ0[1] ALL_PADS Pad
XJ0[1]_Pad_Copper ALL_PADS Pour(Copper)
XJ0[2] ALL_PADS Pad
XJ0[2]_Pad_Copper ALL_PADS Pour(Copper)
XJ0[3] ALL_PADS Pad
XJ0[3]_Pad_Copper ALL_PADS Pour(Copper)
XJ1[0] ALL_PADS Pad
XJ1[0]_Pad_Copper ALL_PADS Pour(Copper)
XJ1[1] ALL_PADS Pad
XJ1[1]_Pad_Copper ALL_PADS Pour(Copper)
XJ1[2] ALL_PADS Pad
XJ1[2]_Pad_Copper ALL_PADS Pour(Copper)
XJ1[3] ALL_PADS Pad
XJ1[3]_Pad_Copper ALL_PADS Pour(Copper)
XJ2[0] ALL_PADS Pad
XJ2[0]_Pad_Copper ALL_PADS Pour(Copper)
XJ2[1] ALL_PADS Pad
XJ2[1]_Pad_Copper ALL_PADS Pour(Copper)
XJ2[2] ALL_PADS Pad
XJ2[2]_Pad_Copper ALL_PADS Pour(Copper)
XJ2[3] ALL_PADS Pad
XJ2[3]_Pad_Copper ALL_PADS Pour(Copper)
XJ3[0] ALL_PADS Pad
XJ3[0]_Pad_Copper ALL_PADS Pour(Copper)
XJ3[1] ALL_PADS Pad
XJ3[1]_Pad_Copper ALL_PADS Pour(Copper)
XJ3[2] ALL_PADS Pad
XJ3[2]_Pad_Copper ALL_PADS Pour(Copper)
XJ3[3] ALL_PADS Pad
XJ3[3]_Pad_Copper ALL_PADS Pour(Copper)

* ========================================
* DEVICE EXTRACTION REQUIRES EXPLICIT BINDINGS
* Use 'device: DeviceName.terminal' property
* ========================================

.end
