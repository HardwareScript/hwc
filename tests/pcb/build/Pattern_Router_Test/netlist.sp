* Hardware Script Native Netlist: Pattern_Router_Test
* Generated by hwc v0.1.6 (Syntax Unification)
* Format: SPICE3

* ========================================
* NETS
* ========================================
* Net: NET_A (pour: P0[0]_Pad_Copper, material: Copper, z: 0.0000mm)
* Net: NET_A (pour: P0[1]_Pad_Copper, material: Copper, z: 0.0000mm)
* Net: NET_A (pour: P0[2]_Pad_Copper, material: Copper, z: 0.0000mm)
* Net: NET_A (pour: P0[3]_Pad_Copper, material: Copper, z: 0.0000mm)
* Net: NET_B (pour: P1[0]_Pad_Copper, material: Copper, z: 0.0000mm)
* Net: NET_B (pour: P1[1]_Pad_Copper, material: Copper, z: 0.0000mm)
* Net: NET_B (pour: P1[2]_Pad_Copper, material: Copper, z: 0.0000mm)
* Net: NET_B (pour: P1[3]_Pad_Copper, material: Copper, z: 0.0000mm)
* Net: NET_A (width=200000nm, material=FR4)
* Net: NET_B (width=200000nm, material=FR4)

* ========================================
* COMPONENTS
* ========================================
XP0[0] NET_A Pad
XP0[0]_Pad_Copper NET_A Pour(Copper)
XP0[1] NET_A Pad
XP0[1]_Pad_Copper NET_A Pour(Copper)
XP0[2] NET_A Pad
XP0[2]_Pad_Copper NET_A Pour(Copper)
XP0[3] NET_A Pad
XP0[3]_Pad_Copper NET_A Pour(Copper)
XP1[0] NET_B Pad
XP1[0]_Pad_Copper NET_B Pour(Copper)
XP1[1] NET_B Pad
XP1[1]_Pad_Copper NET_B Pour(Copper)
XP1[2] NET_B Pad
XP1[2]_Pad_Copper NET_B Pour(Copper)
XP1[3] NET_B Pad
XP1[3]_Pad_Copper NET_B Pour(Copper)

* ========================================
* DEVICE EXTRACTION REQUIRES EXPLICIT BINDINGS
* Use 'device: DeviceName.terminal' property
* ========================================

.end
