* Hardware Script Native Netlist: PCB_ThroughHole_Board
* Generated by hwc v0.1.6 (Syntax Unification)
* Format: SPICE3

* ========================================
* NETS
* ========================================
* Net: NET1 (pour: Top_Pour, material: Copper, z: 0.0000mm)
* Net: NET1 (pour: Bottom_Pour, material: Copper, z: 1.2350mm)

* ========================================
* COMPONENTS
* ========================================
XTop_Pour NET1 Pour(Copper)
XBottom_Pour NET1 Pour(Copper)
XAutoVia_NET1_0_4 NET1 Contact(Copper)

* ========================================
* DEVICE EXTRACTION REQUIRES EXPLICIT BINDINGS
* Use 'device: DeviceName.terminal' property
* ========================================

.end
