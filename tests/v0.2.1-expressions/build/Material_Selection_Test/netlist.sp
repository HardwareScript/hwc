* Hardware Script Native Netlist: Material_Selection_Test
* Generated by hwc v0.1.6 (Syntax Unification)
* Format: SPICE3

* ========================================
* NETS
* ========================================
* Net: POWER (pour: Block_R0_C0, material: Copper, z: 0.0010mm)
* Net: POWER (pour: Block_R0_C1, material: Copper, z: 0.0010mm)
* Net: POWER (pour: Block_R0_C2, material: Copper, z: 0.0010mm)
* Net: POWER (pour: Block_R0_C3, material: Copper, z: 0.0010mm)
* Net: POWER (pour: Block_R1_C0, material: Copper, z: 0.0010mm)
* Net: POWER (pour: Block_R1_C1, material: Gold, z: 0.0010mm)
* Net: POWER (pour: Block_R1_C2, material: Aluminum, z: 0.0010mm)
* Net: POWER (pour: Block_R1_C3, material: Copper, z: 0.0010mm)
* Net: POWER (pour: Block_R2_C0, material: Copper, z: 0.0010mm)
* Net: POWER (pour: Block_R2_C1, material: Aluminum, z: 0.0010mm)
* Net: POWER (pour: Block_R2_C2, material: Aluminum, z: 0.0010mm)
* Net: POWER (pour: Block_R2_C3, material: Copper, z: 0.0010mm)
* Net: POWER (pour: Block_R3_C0, material: Copper, z: 0.0010mm)
* Net: POWER (pour: Block_R3_C1, material: Copper, z: 0.0010mm)
* Net: POWER (pour: Block_R3_C2, material: Copper, z: 0.0010mm)
* Net: POWER (pour: Block_R3_C3, material: Copper, z: 0.0010mm)
* Net: POWER (width=200nm, material=Tungsten)
*   Connected pins:
*     - Block_R0_C0.__virtual_Block_R0_C0
*     - Block_R0_C1.__virtual_Block_R0_C1
*     - Block_R0_C2.__virtual_Block_R0_C2
*     - Block_R0_C3.__virtual_Block_R0_C3
*     - Block_R1_C0.__virtual_Block_R1_C0
*     - Block_R1_C1.__virtual_Block_R1_C1
*     - Block_R1_C2.__virtual_Block_R1_C2
*     - Block_R1_C3.__virtual_Block_R1_C3
*     - Block_R2_C0.__virtual_Block_R2_C0
*     - Block_R2_C1.__virtual_Block_R2_C1
*     - Block_R2_C2.__virtual_Block_R2_C2
*     - Block_R2_C3.__virtual_Block_R2_C3
*     - Block_R3_C0.__virtual_Block_R3_C0
*     - Block_R3_C1.__virtual_Block_R3_C1
*     - Block_R3_C2.__virtual_Block_R3_C2
*     - Block_R3_C3.__virtual_Block_R3_C3

* ========================================
* COMPONENTS (Schematic-Level Subcircuits)
* ========================================
XBlock_R0_C0 POWER Plane(Copper)
XBlock_R0_C1 POWER Plane(Copper)
XBlock_R0_C2 POWER Plane(Copper)
XBlock_R0_C3 POWER Plane(Copper)
XBlock_R1_C0 POWER Plane(Copper)
XBlock_R1_C1 POWER Plane(Gold)
XBlock_R1_C2 POWER Plane(Aluminum)
XBlock_R1_C3 POWER Plane(Copper)
XBlock_R2_C0 POWER Plane(Copper)
XBlock_R2_C1 POWER Plane(Aluminum)
XBlock_R2_C2 POWER Plane(Aluminum)
XBlock_R2_C3 POWER Plane(Copper)
XBlock_R3_C0 POWER Plane(Copper)
XBlock_R3_C1 POWER Plane(Copper)
XBlock_R3_C2 POWER Plane(Copper)
XBlock_R3_C3 POWER Plane(Copper)

* ========================================
* DEVICE EXTRACTION REQUIRES EXPLICIT BINDINGS
* Use 'device: DeviceName.terminal' property
* ========================================

.end
