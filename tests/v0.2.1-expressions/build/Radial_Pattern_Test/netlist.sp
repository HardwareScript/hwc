* Hardware Script Native Netlist: Radial_Pattern_Test
* Generated by hwc v0.1.6 (Syntax Unification)
* Format: SPICE3

* ========================================
* NETS
* ========================================
* Net: CLOCK (pour: Radial_0, material: Copper, z: 0.0010mm)
* Net: CLOCK (pour: Radial_1, material: Copper, z: 0.0010mm)
* Net: CLOCK (pour: Radial_2, material: Copper, z: 0.0010mm)
* Net: CLOCK (pour: Radial_3, material: Copper, z: 0.0010mm)
* Net: CLOCK (pour: Radial_4, material: Copper, z: 0.0010mm)
* Net: CLOCK (pour: Radial_5, material: Copper, z: 0.0010mm)
* Net: CLOCK (pour: Radial_6, material: Copper, z: 0.0010mm)
* Net: CLOCK (pour: Radial_7, material: Copper, z: 0.0010mm)
* Net: CLOCK (width=200nm, material=Tungsten)
*   Connected pins:
*     - Radial_0.__virtual_Radial_0
*     - Radial_1.__virtual_Radial_1
*     - Radial_2.__virtual_Radial_2
*     - Radial_3.__virtual_Radial_3
*     - Radial_4.__virtual_Radial_4
*     - Radial_5.__virtual_Radial_5
*     - Radial_6.__virtual_Radial_6
*     - Radial_7.__virtual_Radial_7

* ========================================
* COMPONENTS (Schematic-Level Subcircuits)
* ========================================
XRadial_0 CLOCK Plane(Copper)
XRadial_1 CLOCK Plane(Copper)
XRadial_2 CLOCK Plane(Copper)
XRadial_3 CLOCK Plane(Copper)
XRadial_4 CLOCK Plane(Copper)
XRadial_5 CLOCK Plane(Copper)
XRadial_6 CLOCK Plane(Copper)
XRadial_7 CLOCK Plane(Copper)

* ========================================
* DEVICE EXTRACTION REQUIRES EXPLICIT BINDINGS
* Use 'device: DeviceName.terminal' property
* ========================================

.end
