* Hardware Script Native Netlist: Center_Between_Test
* Generated by hwc v0.1.6 (Syntax Unification)
* Format: SPICE3

* ========================================
* NETS
* ========================================
* Net: SIGNAL (pour: Pad_A, material: Copper, z: 0.0010mm)
* Net: SIGNAL (pour: Pad_B, material: Copper, z: 0.0010mm)
* Net: SIGNAL (pour: Pad_C, material: Aluminum, z: 0.0010mm)
* Net: SIGNAL (pour: Pad_D, material: Tungsten, z: 0.0010mm)
* Net: SIGNAL (pour: Pad_E, material: Gold, z: 0.0020mm)
* Net: SIGNAL (width=200nm, material=Tungsten)
*   Connected pins:
*     - Pad_A.__virtual_Pad_A
*     - Pad_B.__virtual_Pad_B
*     - Pad_C.__virtual_Pad_C
*     - Pad_D.__virtual_Pad_D
*     - Pad_E.__virtual_Pad_E

* ========================================
* COMPONENTS (Schematic-Level Subcircuits)
* ========================================
XPad_A SIGNAL Plane(Copper)
XPad_B SIGNAL Plane(Copper)
XPad_C SIGNAL Plane(Aluminum)
XPad_D SIGNAL Plane(Tungsten)
XPad_E SIGNAL Plane(Gold)

* ========================================
* DEVICE EXTRACTION REQUIRES EXPLICIT BINDINGS
* Use 'device: DeviceName.terminal' property
* ========================================

.end
