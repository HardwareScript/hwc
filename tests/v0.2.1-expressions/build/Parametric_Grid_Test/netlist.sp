* Hardware Script Native Netlist: Parametric_Grid_Test
* Generated by hwc v0.1.6 (Syntax Unification)
* Format: SPICE3

* ========================================
* NETS
* ========================================
* Net: GND (pour: Grid_R0_C0, material: Copper, z: 0.0010mm)
* Net: GND (pour: Grid_R0_C1, material: Copper, z: 0.0010mm)
* Net: GND (pour: Grid_R0_C2, material: Copper, z: 0.0010mm)
* Net: GND (pour: Grid_R0_C3, material: Copper, z: 0.0010mm)
* Net: GND (pour: Grid_R0_C4, material: Copper, z: 0.0010mm)
* Net: GND (pour: Grid_R1_C0, material: Copper, z: 0.0010mm)
* Net: GND (pour: Grid_R1_C1, material: Copper, z: 0.0010mm)
* Net: GND (pour: Grid_R1_C2, material: Copper, z: 0.0010mm)
* Net: GND (pour: Grid_R1_C3, material: Copper, z: 0.0010mm)
* Net: GND (pour: Grid_R1_C4, material: Copper, z: 0.0010mm)
* Net: GND (pour: Grid_R2_C0, material: Copper, z: 0.0010mm)
* Net: GND (pour: Grid_R2_C1, material: Copper, z: 0.0010mm)
* Net: GND (pour: Grid_R2_C2, material: Copper, z: 0.0010mm)
* Net: GND (pour: Grid_R2_C3, material: Copper, z: 0.0010mm)
* Net: GND (pour: Grid_R2_C4, material: Copper, z: 0.0010mm)
* Net: GND (pour: Grid_R3_C0, material: Copper, z: 0.0010mm)
* Net: GND (pour: Grid_R3_C1, material: Copper, z: 0.0010mm)
* Net: GND (pour: Grid_R3_C2, material: Copper, z: 0.0010mm)
* Net: GND (pour: Grid_R3_C3, material: Copper, z: 0.0010mm)
* Net: GND (pour: Grid_R3_C4, material: Copper, z: 0.0010mm)
* Net: GND (pour: Grid_R4_C0, material: Copper, z: 0.0010mm)
* Net: GND (pour: Grid_R4_C1, material: Copper, z: 0.0010mm)
* Net: GND (pour: Grid_R4_C2, material: Copper, z: 0.0010mm)
* Net: GND (pour: Grid_R4_C3, material: Copper, z: 0.0010mm)
* Net: GND (pour: Grid_R4_C4, material: Copper, z: 0.0010mm)
* Net: GND (width=200nm, material=Tungsten)
*   Connected pins:
*     - Grid_R0_C0.__virtual_Grid_R0_C0
*     - Grid_R0_C1.__virtual_Grid_R0_C1
*     - Grid_R0_C2.__virtual_Grid_R0_C2
*     - Grid_R0_C3.__virtual_Grid_R0_C3
*     - Grid_R0_C4.__virtual_Grid_R0_C4
*     - Grid_R1_C0.__virtual_Grid_R1_C0
*     - Grid_R1_C1.__virtual_Grid_R1_C1
*     - Grid_R1_C2.__virtual_Grid_R1_C2
*     - Grid_R1_C3.__virtual_Grid_R1_C3
*     - Grid_R1_C4.__virtual_Grid_R1_C4
*     - Grid_R2_C0.__virtual_Grid_R2_C0
*     - Grid_R2_C1.__virtual_Grid_R2_C1
*     - Grid_R2_C2.__virtual_Grid_R2_C2
*     - Grid_R2_C3.__virtual_Grid_R2_C3
*     - Grid_R2_C4.__virtual_Grid_R2_C4
*     - Grid_R3_C0.__virtual_Grid_R3_C0
*     - Grid_R3_C1.__virtual_Grid_R3_C1
*     - Grid_R3_C2.__virtual_Grid_R3_C2
*     - Grid_R3_C3.__virtual_Grid_R3_C3
*     - Grid_R3_C4.__virtual_Grid_R3_C4
*     - Grid_R4_C0.__virtual_Grid_R4_C0
*     - Grid_R4_C1.__virtual_Grid_R4_C1
*     - Grid_R4_C2.__virtual_Grid_R4_C2
*     - Grid_R4_C3.__virtual_Grid_R4_C3
*     - Grid_R4_C4.__virtual_Grid_R4_C4

* ========================================
* COMPONENTS (Schematic-Level Subcircuits)
* ========================================
XGrid_R0_C0 GND Plane(Copper)
XGrid_R0_C1 GND Plane(Copper)
XGrid_R0_C2 GND Plane(Copper)
XGrid_R0_C3 GND Plane(Copper)
XGrid_R0_C4 GND Plane(Copper)
XGrid_R1_C0 GND Plane(Copper)
XGrid_R1_C1 GND Plane(Copper)
XGrid_R1_C2 GND Plane(Copper)
XGrid_R1_C3 GND Plane(Copper)
XGrid_R1_C4 GND Plane(Copper)
XGrid_R2_C0 GND Plane(Copper)
XGrid_R2_C1 GND Plane(Copper)
XGrid_R2_C2 GND Plane(Copper)
XGrid_R2_C3 GND Plane(Copper)
XGrid_R2_C4 GND Plane(Copper)
XGrid_R3_C0 GND Plane(Copper)
XGrid_R3_C1 GND Plane(Copper)
XGrid_R3_C2 GND Plane(Copper)
XGrid_R3_C3 GND Plane(Copper)
XGrid_R3_C4 GND Plane(Copper)
XGrid_R4_C0 GND Plane(Copper)
XGrid_R4_C1 GND Plane(Copper)
XGrid_R4_C2 GND Plane(Copper)
XGrid_R4_C3 GND Plane(Copper)
XGrid_R4_C4 GND Plane(Copper)

* ========================================
* DEVICE EXTRACTION REQUIRES EXPLICIT BINDINGS
* Use 'device: DeviceName.terminal' property
* ========================================

.end
