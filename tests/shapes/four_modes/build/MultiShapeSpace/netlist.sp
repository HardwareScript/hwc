* Hardware Script Native Netlist: MultiShapeSpace
* Generated by hwc v0.1.6 (Syntax Unification)
* Format: SPICE3

* ========================================
* NETS
* ========================================
* Net: NET_C1a_p_to_C1b_p (width=100000nm, material=Copper)
* Net: NET_D1a_p_to_D1b_p (width=100000nm, material=Copper)
* Net: NET_T1a_p_to_T1b_p (width=100000nm, material=Copper)
* Net: NET_O1a_p_to_O1b_p (width=100000nm, material=Copper)

* ========================================
* COMPONENTS
* ========================================
XC1a NET_C1a_p_to_C1b_p Pad
XC1b NET_C1a_p_to_C1b_p Pad
XD1a NET_D1a_p_to_D1b_p Pad
XD1b NET_D1a_p_to_D1b_p Pad
XT1a NET_T1a_p_to_T1b_p Pad
XT1b NET_T1a_p_to_T1b_p Pad
XO1a NET_O1a_p_to_O1b_p Pad
XO1b NET_O1a_p_to_O1b_p Pad
XS1a NET_S1a_p_to_S1b_p Pad
XS1b NET_S1a_p_to_S1b_p Pad

* ========================================
* DEVICE EXTRACTION REQUIRES EXPLICIT BINDINGS
* Use 'device: DeviceName.terminal' property
* ========================================

.end
