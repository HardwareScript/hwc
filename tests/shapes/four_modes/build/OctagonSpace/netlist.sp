* Hardware Script Native Netlist: OctagonSpace
* Generated by hwc v0.1.6 (Syntax Unification)
* Format: SPICE3

* ========================================
* NETS
* ========================================

* ========================================
* COMPONENTS
* ========================================
XP1 NET_P1_p_to_P2_p Pad
XP2 NET_P1_p_to_P2_p Pad
XAutoVia_NET_P1_p_to_P2_p_0_2 NET_P1_p_to_P2_p Contact(Copper)
XAutoVia_NET_P1_p_to_P2_p_0_2 NET_P1_p_to_P2_p Contact(Copper)

* ========================================
* DEVICE EXTRACTION REQUIRES EXPLICIT BINDINGS
* Use 'device: DeviceName.terminal' property
* ========================================

.end
