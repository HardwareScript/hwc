* Hardware Script DC Operating Point Test
* Space: Crosstalk_Violation_Space
* Generated by hwc v0.2.1
* Format: SPICE3

.include "circuit.sp"

* ========================================
* STIMULUS & ANALYSIS
* ========================================
V_Clock nClock_entry 0 DC 1.800
V_Data nData_entry 0 DC 1.800
.op
.end
