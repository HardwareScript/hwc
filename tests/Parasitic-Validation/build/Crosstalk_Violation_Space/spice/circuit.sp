* Hardware Script Pure Circuit (DUT)
* Space: Crosstalk_Violation_Space
* Generated by hwc v0.2.1
* Format: SPICE3

* ========================================
* NETS
* ========================================
* Net: Clock (pour: Clock_In_Pad, material: Aluminum_Met1, z: 0nm)
* Net: Clock_Out (pour: Clock_Out_Pad, material: Aluminum_Met1, z: 0nm)
* Net: Data (pour: Data_In_Pad, material: Aluminum_Met1, z: 0nm)
* Net: Data_Out (pour: Data_Out_Pad, material: Aluminum_Met1, z: 0nm)
* Net: Clock (width=200nm, material=Tungsten)
*   Connected pins:
*     - Clock_In_Pad.anchor
*     - Clock_In_Pad.__virtual_Clock_In_Pad
* Net: Clock_Out (width=200nm, material=Tungsten)
*   Connected pins:
*     - Clock_Out_Pad.anchor
*     - Clock_Out_Pad.__virtual_Clock_Out_Pad
* Net: Data (width=200nm, material=Tungsten)
*   Connected pins:
*     - Data_In_Pad.anchor
*     - Data_In_Pad.__virtual_Data_In_Pad
* Net: Data_Out (width=200nm, material=Tungsten)
*   Connected pins:
*     - Data_Out_Pad.anchor
*     - Data_Out_Pad.__virtual_Data_Out_Pad

* ========================================
* INTEGRATED TRACE PARASITICS
* ========================================
* Trace resistance
RRtr_Data_0 nData_entry Data 3.760000e0
* Trace resistance
RRtr_Clock_0 nClock_entry Clock 3.760000e0

* Total parasitic elements: 2

.end
