* Hardware Script Transient Waveform Test
* Space: Parasitic_Extraction_Space
* Generated by hwc v0.1.6
* Format: SPICE3

* ========================================
* NETS
* ========================================
* Net: In (pour: In_Pad, material: Copper, z: 0.0000mm)
* Net: In (pour: Mid_Node, material: Copper, z: 0.0010mm)
* Net: Out (pour: Out_Pad, material: Copper, z: 0.0000mm)
* Net: In (width=500nm, material=Tungsten)
*   Connected pins:
*     - In_Pad.anchor
*     - In_Pad.__virtual_In_Pad
*     - Mid_Node.anchor
*     - Mid_Node.__virtual_Mid_Node
*     - Via_Up.__virtual_Via_Up
*     - Via_Down.__virtual_Via_Down
*     - In_Pad.__virtual_In_Pad
*     - Via_Up.__virtual_Via_Up
*     - Mid_Node.__virtual_Mid_Node
*     - Via_Down.__virtual_Via_Down
*     - In_Pad.__virtual_In_Pad
*     - Via_Up.__virtual_Via_Up
*     - Mid_Node.__virtual_Mid_Node
*     - Via_Down.__virtual_Via_Down
* Net: Out (width=500nm, material=Tungsten)
*   Connected pins:
*     - Out_Pad.anchor
*     - Out_Pad.__virtual_Out_Pad
* Net: TEMP_NET (width=500nm, material=Tungsten)

* ========================================
* EXTRACTED TRACE PARASITICS
* Auto-extracted from routing geometry
* ========================================
RRIn_0_1 NIn_0_1 NIn_0_1_E 5.040000e-2  * Trace resistance
CCIn_0_1 NIn_0_1_E 0 2.589850e-17  * Ground capacitance
RRIn_0_3 NIn_0_3 NIn_0_3_E 1.680000e-2  * Trace resistance
RRIn_0_4 NIn_0_4 NIn_0_4_E 5.275221e-1  * Trace resistance
LLIn_0_4 NIn_0_4 NIn_0_4_E 4.152725e-13  * Via inductance
RRIn_0_5 NIn_0_5 NIn_0_5_E 6.720000e-2  * Trace resistance
LLIn_0_5 NIn_0_5 NIn_0_5_E 4.158883e-13  * Via inductance
RRIn_0_6 NIn_0_6 NIn_0_6_E 5.040000e-2  * Trace resistance
CCIn_0_6 NIn_0_6_E 0 2.589850e-17  * Ground capacitance
RRIn_0_7 NIn_0_7 NIn_0_7_E 6.720000e-2  * Trace resistance
LLIn_0_7 NIn_0_7 NIn_0_7_E 4.158883e-13  * Via inductance
RRIn_0_8 NIn_0_8 NIn_0_8_E 1.680000e-2  * Trace resistance

* Total parasitic elements extracted: 12

* ========================================
* STIMULUS & ANALYSIS
* ========================================
Vgnd GND 0 0
.tran 200ns
.plot tran V(In) V(Out)
.end
