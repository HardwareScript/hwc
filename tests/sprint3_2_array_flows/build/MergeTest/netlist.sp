* Hardware Script Native Netlist: MergeTest
* Generated by hwc v0.1.6 (Syntax Unification)
* Format: SPICE3

* ========================================
* NETS
* ========================================
* Net: GND (pour: F_Array[0]_SharedRegion, material: Silicon_N, layer: 1)
* Net: GND (pour: F_Array[1]_SharedRegion, material: Silicon_N, layer: 1)
* Net: GND (pour: F_Array[2]_SharedRegion, material: Silicon_N, layer: 1)
* Net: GND (pour: F_Array[0-2].SharedRegion, material: Silicon_N, layer: 1)

* ========================================
* COMPONENTS
* ========================================
XF_Array[0] nc_0 nc_1 OverlapFinger
XF_Array[0]_SharedRegion GND Pour(Silicon_N)
XF_Array[1] nc_3 nc_4 OverlapFinger
XF_Array[1]_SharedRegion GND Pour(Silicon_N)
XF_Array[2] nc_6 nc_7 OverlapFinger
XF_Array[2]_SharedRegion GND Pour(Silicon_N)

* ========================================
* DEVICE EXTRACTION REQUIRES EXPLICIT BINDINGS
* Use 'device: DeviceName.terminal' property
* ========================================

.end
