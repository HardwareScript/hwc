* Hardware Script Native Netlist: MergedRegionTest
* Generated by hwc v0.1.6 (Syntax Unification)
* Format: SPICE3

* ========================================
* NETS
* ========================================
* Net: GND (merged region: F_Array[0-2].source, 1 instances, total area: 50000000 nm², material: Silicon_N, layer: 1)
*   Parasitic extraction: Treat as single electrical node
* Net: GND (pour: F_Array[0]_source, material: Silicon_N, layer: 1)
* Net: GND (pour: F_Array[1]_source, material: Silicon_N, layer: 1)
* Net: GND (pour: F_Array[2]_source, material: Silicon_N, layer: 1)

* ========================================
* COMPONENTS
* ========================================
XF_Array[0] nc_0 nc_1 Finger
XF_Array[0]_source GND Pour(Silicon_N)
XF_Array[1] nc_3 nc_4 Finger
XF_Array[1]_source GND Pour(Silicon_N)
XF_Array[2] nc_6 nc_7 Finger
XF_Array[2]_source GND Pour(Silicon_N)

* ========================================
* DEVICE EXTRACTION REQUIRES EXPLICIT BINDINGS
* Use 'device: DeviceName.terminal' property
* ========================================

.end
