* Hardware Script Native Netlist: ViaToPadBoard
* Generated by hwc v0.1.6 (Syntax Unification)
* Format: SPICE3

* ========================================
* NETS
* ========================================
* Net: NET_Via_A_Anchor_P_to_Pad_B_P (pour: Pad_B_Pad, material: Copper, z: 1.5350mm)
* Net: NET_A (width=100000nm, material=Copper)

* ========================================
* COMPONENTS
* ========================================
XVia_A NET_A Contact(Copper)
XVia_A_Anchor NET_Via_A_Anchor_P_to_Pad_B_P Pin
XPad_B NET_Via_A_Anchor_P_to_Pad_B_P RectPad

* ========================================
* DEVICE EXTRACTION REQUIRES EXPLICIT BINDINGS
* Use 'device: DeviceName.terminal' property
* ========================================

.end
