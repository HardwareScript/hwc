* Hardware Script Native Netlist: RingToPadBoard
* Generated by hwc v0.1.6 (Syntax Unification)
* Format: SPICE3

* ========================================
* NETS
* ========================================
* Net: NET_Ring_A_P_to_Pad_B_P (pour: Ring_A_Ring, material: Copper, z: 1.5350mm)
* Net: NET_Ring_A_P_to_Pad_B_P (pour: Pad_B_Pad, material: Copper, z: 1.5350mm)

* ========================================
* COMPONENTS
* ========================================
XRing_A NET_Ring_A_P_to_Pad_B_P RingPad
XPad_B NET_Ring_A_P_to_Pad_B_P RectPad

* ========================================
* DEVICE EXTRACTION REQUIRES EXPLICIT BINDINGS
* Use 'device: DeviceName.terminal' property
* ========================================

.end
