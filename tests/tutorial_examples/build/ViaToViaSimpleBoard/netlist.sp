* Hardware Script Native Netlist: ViaToViaSimpleBoard
* Generated by hwc v0.1.6 (Syntax Unification)
* Format: SPICE3

* ========================================
* NETS
* ========================================
* Net: NET_V2V (width=100000nm, material=Copper)

* ========================================
* COMPONENTS
* ========================================
XVia_A NET_V2V Contact(Copper)
XVia_A_Anchor NET_Via_A_Anchor_P_to_Via_B_Anchor_P Pin
XVia_B NET_V2V Contact(Copper)
XVia_B_Anchor NET_Via_A_Anchor_P_to_Via_B_Anchor_P Pin

* ========================================
* DEVICE EXTRACTION REQUIRES EXPLICIT BINDINGS
* Use 'device: DeviceName.terminal' property
* ========================================

.end
