* Hardware Script Native Netlist: PadToViaBoard
* Generated by hwc v0.1.6 (Syntax Unification)
* Format: SPICE3

* ========================================
* NETS
* ========================================
* Net: SIG (pour: Pad_A_Copper, material: Copper, z: 1.5350mm)
* Net: SIG (width=100000nm, material=Copper)

* ========================================
* COMPONENTS
* ========================================
XPad_A_Copper SIG Pour(Copper)
XA NET_A_P_to_B_P Pin
XTarget_Via SIG Contact(Copper)
XB NET_A_P_to_B_P Pin

* ========================================
* DEVICE EXTRACTION REQUIRES EXPLICIT BINDINGS
* Use 'device: DeviceName.terminal' property
* ========================================

.end
