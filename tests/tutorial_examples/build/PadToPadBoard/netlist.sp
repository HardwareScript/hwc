* Hardware Script Native Netlist: PadToPadBoard
* Generated by hwc v0.1.6 (Syntax Unification)
* Format: SPICE3

* ========================================
* NETS
* ========================================

* ========================================
* COMPONENTS
* ========================================
XPad_A NET_Pad_A_P_to_Pad_B_P RoundPin
XPad_B NET_Pad_A_P_to_Pad_B_P RoundPin

* ========================================
* DEVICE EXTRACTION REQUIRES EXPLICIT BINDINGS
* Use 'device: DeviceName.terminal' property
* ========================================

.end
