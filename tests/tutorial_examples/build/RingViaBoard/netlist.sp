* Hardware Script Native Netlist: RingViaBoard
* Generated by hwc v0.1.6 (Syntax Unification)
* Format: SPICE3

* ========================================
* NETS
* ========================================
* Net: NET_Ring_N_to_ViaNAnchor_P (pour: Ring_Wing, material: Copper, z: 1.5350mm)
* Net: NET_VIA_N (width=100000nm, material=Copper)
* Net: NET_VIA_S (width=100000nm, material=Copper)
* Net: NET_VIA_E (width=100000nm, material=Copper)
* Net: NET_VIA_W (width=100000nm, material=Copper)
* Net: NET_Ring_N_to_ViaNAnchor_P (width=100000nm, material=Copper)
* Net: NET_Ring_S_to_ViaSAnchor_P (width=100000nm, material=Copper)
* Net: NET_Ring_E_to_ViaEAnchor_P (width=100000nm, material=Copper)

* ========================================
* COMPONENTS
* ========================================
XRing NET_Ring_N_to_ViaNAnchor_P NET_Ring_S_to_ViaSAnchor_P NET_Ring_E_to_ViaEAnchor_P NET_Ring_W_to_ViaWAnchor_P MidWing
XViaN NET_VIA_N Contact(Copper)
XViaNAnchor NET_Ring_N_to_ViaNAnchor_P Pin
XViaS NET_VIA_S Contact(Copper)
XViaSAnchor NET_Ring_S_to_ViaSAnchor_P Pin
XViaE NET_VIA_E Contact(Copper)
XViaEAnchor NET_Ring_E_to_ViaEAnchor_P Pin
XViaW NET_VIA_W Contact(Copper)
XViaWAnchor NET_Ring_W_to_ViaWAnchor_P Pin

* ========================================
* DEVICE EXTRACTION REQUIRES EXPLICIT BINDINGS
* Use 'device: DeviceName.terminal' property
* ========================================

.end
