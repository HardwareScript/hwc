* Hardware Script Native Netlist: BigViaBoard
* Generated by hwc v0.1.6 (Syntax Unification)
* Format: SPICE3

* ========================================
* NETS
* ========================================
* Net: NET_BIG_VIA (width=100000nm, material=Copper)
* Net: NET_VIA_N (width=100000nm, material=Copper)
* Net: NET_VIA_S (width=100000nm, material=Copper)
* Net: NET_VIA_E (width=100000nm, material=Copper)
* Net: NET_VIA_W (width=100000nm, material=Copper)

* ========================================
* COMPONENTS
* ========================================
XBigVia NET_BIG_VIA Contact(Copper)
XBigViaAnchor NET_BigViaAnchor_P_to_ViaNAnchor_P Pin
XViaN NET_VIA_N Contact(Copper)
XViaNAnchor NET_BigViaAnchor_P_to_ViaNAnchor_P Pin
XViaS NET_VIA_S Contact(Copper)
XViaSAnchor NET_BigViaAnchor_P_to_ViaNAnchor_P Pin
XViaE NET_VIA_E Contact(Copper)
XViaEAnchor NET_BigViaAnchor_P_to_ViaNAnchor_P Pin
XViaW NET_VIA_W Contact(Copper)
XViaWAnchor NET_BigViaAnchor_P_to_ViaNAnchor_P Pin

* ========================================
* DEVICE EXTRACTION REQUIRES EXPLICIT BINDINGS
* Use 'device: DeviceName.terminal' property
* ========================================

.end
