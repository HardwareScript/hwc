* Hardware Script DC Sweep Analysis Test
* Space: Simple_Diode_Space
* Generated by hwc v0.3.1
* Format: SPICE3

.include "circuit.sp"

* ========================================
* STIMULUS & ANALYSIS
* ========================================
V_Anode_In Anode_In 0 DC 1.8000e0
I_load_Cathode_Out Cathode_Out 0 DC 1.0000e-6
.dc V_Anode_In 0.0000e0 1.8000e0 2.0000e-2
.end
