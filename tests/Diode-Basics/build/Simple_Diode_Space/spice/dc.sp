* Hardware Script DC Sweep Analysis Test
* Space: Simple_Diode_Space
* Generated by hwc v0.2.1
* Format: SPICE3

.include "circuit.sp"

* ========================================
* STIMULUS & ANALYSIS
* ========================================
V_Anode_In Anode_In 0 DC 0.0000e0
.dc V_Anode_In 0.0000e0 1.8000e0 2.0000e-2
.end
