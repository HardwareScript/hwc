* Hardware Script Pure Circuit (DUT)
* Space: Simple_Diode_Space
* Generated by hwc v0.2.1
* Format: SPICE3

* ========================================
* NETS
* ========================================
* Net: Anode_In (pour: Anode_Region, material: Silicon_P, z: 0nm)
* Net: Cathode_Out (pour: Cathode_Region, material: Silicon_P, z: 0nm)
* Net: Anode_In (pour: Contact_Anode_LI, material: Titanium_Silicide, z: 400nm)
* Net: Anode_In (pour: Contact_Anode_Metal, material: Aluminum, z: 650nm)
* Net: Cathode_Out (pour: Contact_Cathode_LI, material: Titanium_Silicide, z: 400nm)
* Net: Cathode_Out (pour: Contact_Cathode_Metal, material: Aluminum, z: 650nm)
* Net: Anode_In (pour: Anode_Pad, material: Aluminum, z: 650nm)
* Net: Cathode_Out (pour: Cathode_Pad, material: Aluminum, z: 650nm)
* Net: Anode_In (width=300nm, material=Aluminum)
*   Connected pins:
*     - Anode_Region.anchor
*     - Anode_Region.__virtual_Anode_Region
*     - Contact_Anode_LI.anchor
*     - Contact_Anode_LI.__virtual_Contact_Anode_LI
*     - Contact_Anode_Metal.anchor
*     - Contact_Anode_Metal.__virtual_Contact_Anode_Metal
*     - Anode_Pad.anchor
*     - Anode_Pad.__virtual_Anode_Pad
*     - Via_Anode_Active_LI.__virtual_Via_Anode_Active_LI
*     - Via_Anode_LI_Metal.__virtual_Via_Anode_LI_Metal
* Net: Cathode_Out (width=300nm, material=Aluminum)
*   Connected pins:
*     - Cathode_Region.anchor
*     - Cathode_Region.__virtual_Cathode_Region
*     - Contact_Cathode_LI.anchor
*     - Contact_Cathode_LI.__virtual_Contact_Cathode_LI
*     - Contact_Cathode_Metal.anchor
*     - Contact_Cathode_Metal.__virtual_Contact_Cathode_Metal
*     - Cathode_Pad.anchor
*     - Cathode_Pad.__virtual_Cathode_Pad
*     - Via_Cathode_Active_LI.__virtual_Via_Cathode_Active_LI
*     - Via_Cathode_LI_Metal.__virtual_Via_Cathode_LI_Metal

* ========================================
* EXTRACTED DEVICES
* ========================================
XD1 nAnode_In_active nCathode_Out_active Diode

* ========================================
* INTEGRATED TRACE PARASITICS
* ========================================
* Via/Contact resistance
Rvia_Anode_In_li1_metal1 nAnode_In_metal1 nAnode_In_li1 3.460208e1
* Via/Contact resistance
Rvia_Anode_In_active_li1 nAnode_In_li1 nAnode_In_active 3.460208e1
* Via/Contact resistance
Rvia_Cathode_Out_li1_metal1 nCathode_Out_metal1 nCathode_Out_li1 3.460208e1
* Via/Contact resistance
Rvia_Cathode_Out_active_li1 nCathode_Out_li1 nCathode_Out_active 3.460208e1
* Trace resistance
Rtr_Anode_In_0_0 Anode_In nAnode_In_metal1 7.311111e-1
* Ground capacitance
Cgnd_Anode_In_0_0 nAnode_In_metal1 Cathode_Out 1.933755e-16
* Trace resistance
Rtr_Cathode_Out_1_0 nCathode_Out_metal1 Cathode_Out 7.311111e-1
* Ground capacitance
Cgnd_pour_Contact_Anode_Metal nAnode_In_metal1 Cathode_Out 3.683342e-17
* Ground capacitance
Cgnd_pour_Anode_Pad Anode_In Cathode_Out 2.302089e-16

* Total parasitic elements: 9

.end
