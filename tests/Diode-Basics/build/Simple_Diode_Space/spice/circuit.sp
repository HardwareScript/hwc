* Hardware Script Pure Circuit (DUT)
* Space: Simple_Diode_Space
* Generated by hwc v0.3.1
* Format: SPICE3

* ========================================
* NETS
* ========================================
* Net: Anode_In (pour: sky130_diode, material: Silicon_P, z: 0nm)
* Net: Cathode_Out (pour: sky130_diode, material: Silicon_P, z: 0nm)
* Net: Anode_In (pour: sky130_diode, material: Titanium_Silicide, z: 400nm)
* Net: Anode_In (pour: sky130_diode, material: Aluminum, z: 650nm)
* Net: Cathode_Out (pour: sky130_diode, material: Titanium_Silicide, z: 400nm)
* Net: Cathode_Out (pour: sky130_diode, material: Aluminum, z: 650nm)
* Net: Anode_In (pour: pad, material: Aluminum, z: 650nm)
* Net: Anode_In (pour: pad, material: Pad_Mask, z: 1.01µm)
* Net: Cathode_Out (pour: pad, material: Aluminum, z: 650nm)
* Net: Cathode_Out (pour: pad, material: Pad_Mask, z: 1.01µm)
* Net: Anode_In (width=300nm, material=Aluminum)
*   Connected pins:
*     - sky130_diode.anchor
*     - sky130_diode.__virtual_sky130_diode
*     - sky130_diode.anchor
*     - sky130_diode.__virtual_sky130_diode
*     - sky130_diode.anchor
*     - sky130_diode.__virtual_sky130_diode
*     - pad.anchor
*     - pad.__virtual_pad
*     - pad.anchor
*     - pad.__virtual_pad
*     - .__virtual_
*     - .__virtual_
* Net: Cathode_Out (width=300nm, material=Aluminum)
*   Connected pins:
*     - sky130_diode.anchor
*     - sky130_diode.__virtual_sky130_diode
*     - sky130_diode.anchor
*     - sky130_diode.__virtual_sky130_diode
*     - sky130_diode.anchor
*     - sky130_diode.__virtual_sky130_diode
*     - pad.anchor
*     - pad.__virtual_pad
*     - pad.anchor
*     - pad.__virtual_pad
*     - .__virtual_
*     - .__virtual_

* ========================================
* EXTRACTED DEVICES
* ========================================
Xsky130_diode 0 0 Diode

* ========================================
* INTEGRATED TRACE PARASITICS
* ========================================
* Via/Contact resistance
Rvia_Anode_In_li1_metal1 nAnode_In_metal1 nAnode_In_li1 3.460208e1
* Via/Contact resistance
Rvia_Anode_In_active_li1 nAnode_In_li1 nAnode_In_active 3.460208e1
* Via/Contact resistance
Rvia_Cathode_Out_li1_metal1 nCathode_Out_metal1 nCathode_Out_li1 3.460208e1
* Via/Contact resistance
Rvia_Cathode_Out_active_li1 nCathode_Out_li1 nCathode_Out_active 3.460208e1
* Trace resistance
Rtr_Anode_In_0_0 Anode_In nAnode_In_metal1 9.791667e-1
* Ground capacitance
Cgnd_Anode_In_0_0 nAnode_In_metal1 Cathode_Out 2.589850e-16
* Trace resistance
Rtr_Cathode_Out_1_0 nCathode_Out_metal1 Cathode_Out 9.791667e-1
* Ground capacitance
Cgnd_pour_sky130_diode nAnode_In_metal1 Cathode_Out 3.683342e-17
* Ground capacitance
Cgnd_pour_pad Anode_In Cathode_Out 2.302089e-16
* Ground capacitance
Cgnd_pour_pad Anode_In Cathode_Out 8.287520e-17

* Total parasitic elements: 10

* ========================================
* NET BRIDGES (STIMULUS TO PHYSICAL TRACES)
* ========================================
V_bridge_Anode_In Anode_In nAnode_In_metal1 DC 0

.end
