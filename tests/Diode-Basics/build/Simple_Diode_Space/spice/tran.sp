* Hardware Script Transient Waveform Test
* Space: Simple_Diode_Space
* Generated by hwc v0.2.1
* Format: SPICE3

.include "circuit.sp"

* ========================================
* STIMULUS & ANALYSIS
* ========================================
V_Anode_In Anode_In 0 PULSE(0.0 1.800 0.0 1.000e-10 1.000e-10 1.000e-7 2.000e-7)
.tran 1.000e-11 2.000e-7
.end
