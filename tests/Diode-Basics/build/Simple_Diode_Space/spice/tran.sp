* Hardware Script Transient Waveform Test
* Space: Simple_Diode_Space
* Generated by hwc v0.3.1
* Format: SPICE3

.include "circuit.sp"

* ========================================
* STIMULUS & ANALYSIS
* ========================================
V_Anode_In Anode_In 0 PULSE(0.0000e0 1.8000e0 0.000e0 1.000e-10 1.000e-10 1.000e-7 2.000e-7)
I_load_Cathode_Out Cathode_Out 0 DC 1.0000e-6
.tran 1.000e-11 2.000e-7
.end
