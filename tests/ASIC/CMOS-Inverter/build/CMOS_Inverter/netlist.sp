* Hardware Script Native Netlist: CMOS_Inverter
* Generated by hwc v0.1.6 (Syntax Unification)
* Format: SPICE3

* ========================================
* NETS
* ========================================
* Net: VIN (pour: VIN_Pad, material: Aluminum, z: 0.3009mm)
* Net: VOUT (pour: VOUT_Pad, material: Aluminum, z: 0.3009mm)
* Net: VDD (pour: VDD_Rail, material: Aluminum, z: 0.3009mm)
* Net: GND (pour: GND_Rail, material: Aluminum, z: 0.3009mm)
* Net: VIN (width=100000nm, material=Aluminum)
* Net: VOUT (width=100000nm, material=Aluminum)
* Net: VDD (width=100000nm, material=Aluminum)
* Net: GND (width=100000nm, material=Aluminum)

* ========================================
* EXTRACTED DEVICES (Transistors)
* ========================================
MM1 VOUT VIN GND GND NMOS W=0.44u L=0.44u AS=5.18e-13 AD=5.18e-13 PS=3.12e-6 PD=3.12e-6
MM2 VOUT VIN VDD VDD PMOS W=0.44u L=0.44u AS=5.18e-13 AD=5.18e-13 PS=3.12e-6 PD=3.12e-6

* ========================================
* AUTOMATIC STIMULUS & MODELS
* ========================================
Vgnd GND 0 0
.end
