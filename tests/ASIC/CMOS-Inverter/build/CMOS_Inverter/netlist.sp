* Hardware Script Native Netlist: CMOS_Inverter
* Generated by hwc v0.1.6 (Syntax Unification)
* Format: SPICE3

* ========================================
* NETS
* ========================================
* Net: NET_M1_gate_to_M2_gate (pour: M1_Gate_Poly, material: Polysilicon, z: 0.3000mm)
* Net: NET_M1_drain_to_M2_drain (pour: M1_Drain_Diff, material: Silicon_N, z: 0.3000mm)
* Net: NET_M1_gate_to_M2_gate (pour: M2_Gate_Poly, material: Polysilicon, z: 0.3000mm)
* Net: NET_M1_drain_to_M2_drain (pour: M2_Drain_Diff, material: Silicon_P, z: 0.3000mm)
* Net: NET_M1_gate_to_M2_gate (width=100000nm, material=Copper)
* Net: NET_M1_drain_to_M2_drain (width=100000nm, material=Copper)

* ========================================
* EXTRACTED DEVICES (Transistors)
* ========================================
MM1 VOUT VIN GND GND NMOS W=0.45u L=0.45u AS=4.50e-13 AD=4.50e-13 PS=2.80e-6 PD=2.80e-6
MM2 VOUT VIN VDD VDD PMOS W=0.45u L=0.45u AS=4.50e-13 AD=4.50e-13 PS=2.80e-6 PD=2.80e-6

* ========================================
* AUTOMATIC STIMULUS & MODELS
* ========================================
Vgnd GND 0 0
.end
