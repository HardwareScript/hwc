* Hardware Script Native Netlist: CapacitorTest
* Generated by hwc v0.1.6 (Syntax Unification)
* Format: SPICE3

* ========================================
* NETS
* ========================================
* Net: P1 (pour: BottomPlate, material: Aluminum, z: 0.0002mm)
* Net: P2 (pour: TopPlate, material: Copper, z: 0.0003mm)
* Net: P1 (pour: BottomPad, material: Aluminum, z: 0.0002mm)
* Net: P2 (pour: TopPad, material: Copper, z: 0.0003mm)
* Net: P1 (width=200nm, material=Silicon_Dioxide)
*   Connected pins:
*     - BottomPlate.anchor
*     - BottomPad.anchor
*     - BottomPad.anchor
*     - BottomPlate.anchor
* Net: P2 (width=200nm, material=Silicon_Dioxide)
*   Connected pins:
*     - TopPlate.anchor
*     - TopPad.anchor
*     - TopPad.anchor
*     - TopPlate.anchor

* ========================================
* AUTOMATIC STIMULUS & MODELS
* ========================================
Vgnd GND 0 0
.end
