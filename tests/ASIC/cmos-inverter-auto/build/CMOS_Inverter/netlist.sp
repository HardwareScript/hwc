* Hardware Script Native Netlist: CMOS_Inverter
* Generated by hwc v0.1.6 (Syntax Unification)
* Format: SPICE3

* ========================================
* NETS
* ========================================
* Net: GND (pour: M1_Source_Diff, material: Silicon_N, z: 0.0001mm)
* Net: VIN (pour: M1_Gate_Poly, material: Polysilicon, z: 0.0003mm)
* Net: VOUT (pour: M1_Drain_Diff, material: Silicon_N, z: 0.0001mm)
* Net: GND (pour: M1_Bulk_Contact, material: Silicon_P, z: 0.0001mm)
* Net: GND (pour: M1_Source_Pad, material: Aluminum, z: 0.0010mm)
* Net: VIN (pour: M1_Gate_Pad, material: Aluminum, z: 0.0010mm)
* Net: VOUT (pour: M1_Drain_Pad, material: Aluminum, z: 0.0010mm)
* Net: GND (pour: M1_Bulk_Pad, material: Aluminum, z: 0.0010mm)
* Net: VDD (pour: M2_Source_Diff, material: Silicon_P, z: 0.0001mm)
* Net: VIN (pour: M2_Gate_Poly, material: Polysilicon, z: 0.0003mm)
* Net: VOUT (pour: M2_Drain_Diff, material: Silicon_P, z: 0.0001mm)
* Net: VDD (pour: M2_Bulk_Contact, material: Silicon_N, z: 0.0001mm)
* Net: VDD (pour: M2_Source_Pad, material: Aluminum, z: 0.0010mm)
* Net: VIN (pour: M2_Gate_Pad, material: Aluminum, z: 0.0010mm)
* Net: VOUT (pour: M2_Drain_Pad, material: Aluminum, z: 0.0010mm)
* Net: VDD (pour: M2_Bulk_Pad, material: Aluminum, z: 0.0010mm)
* Net: GND (pour: GND_Rail, material: Aluminum, z: 0.0010mm)
* Net: VDD (pour: VDD_Rail, material: Aluminum, z: 0.0010mm)
* Net: VIN (pour: VIN_Pad, material: Aluminum, z: 0.0010mm)
* Net: VOUT (pour: VOUT_Pad, material: Aluminum, z: 0.0010mm)
* Net: VIN (width=250nm, material=Tungsten)
*   Connected pins:
*     - M1.gate
*     - M1_Gate_Poly.anchor
*     - M1_Gate_Poly.__virtual_M1_Gate_Poly
*     - M1.gate
*     - M1_Gate_Pad.anchor
*     - M1_Gate_Pad.__virtual_M1_Gate_Pad
*     - M1.gate
*     - M2.gate
*     - M2_Gate_Poly.anchor
*     - M2_Gate_Poly.__virtual_M2_Gate_Poly
*     - M2.gate
*     - M2_Gate_Pad.anchor
*     - M2_Gate_Pad.__virtual_M2_Gate_Pad
*     - M2.gate
*     - VIN_Pad.anchor
*     - VIN_Pad.__virtual_VIN_Pad
*     - M1.gate
*     - VIN_Pad.__virtual_VIN_Pad
*     - M2.gate
*     - VIN_Pad.__virtual_VIN_Pad
*     - M1.gate
*     - VIN_Pad.__virtual_VIN_Pad
*     - M2.gate
*     - VIN_Pad.__virtual_VIN_Pad
* Net: VOUT (width=250nm, material=Tungsten)
*   Connected pins:
*     - M1.drain
*     - M1_Drain_Diff.anchor
*     - M1_Drain_Diff.__virtual_M1_Drain_Diff
*     - M1.drain
*     - M1_Drain_Pad.anchor
*     - M1_Drain_Pad.__virtual_M1_Drain_Pad
*     - M1.drain
*     - M2.drain
*     - M2_Drain_Diff.anchor
*     - M2_Drain_Diff.__virtual_M2_Drain_Diff
*     - M2.drain
*     - M2_Drain_Pad.anchor
*     - M2_Drain_Pad.__virtual_M2_Drain_Pad
*     - M2.drain
*     - VOUT_Pad.anchor
*     - VOUT_Pad.__virtual_VOUT_Pad
*     - M1.drain
*     - VOUT_Pad.__virtual_VOUT_Pad
*     - M2.drain
*     - VOUT_Pad.__virtual_VOUT_Pad
*     - M1.drain
*     - VOUT_Pad.__virtual_VOUT_Pad
*     - M2.drain
*     - VOUT_Pad.__virtual_VOUT_Pad
* Net: VDD (width=250nm, material=Tungsten)
*   Connected pins:
*     - M2.bulk
*     - M2.source
*     - M2_Source_Diff.anchor
*     - M2_Source_Diff.__virtual_M2_Source_Diff
*     - M2.source
*     - M2_Bulk_Contact.anchor
*     - M2_Bulk_Contact.__virtual_M2_Bulk_Contact
*     - M2.bulk
*     - M2_Source_Pad.anchor
*     - M2_Source_Pad.__virtual_M2_Source_Pad
*     - M2.source
*     - M2_Bulk_Pad.anchor
*     - M2_Bulk_Pad.__virtual_M2_Bulk_Pad
*     - M2.bulk
*     - VDD_Rail.anchor
*     - VDD_Rail.__virtual_VDD_Rail
*     - M2.source
*     - VDD_Rail.__virtual_VDD_Rail
*     - M2.bulk
*     - VDD_Rail.__virtual_VDD_Rail
*     - M2.source
*     - VDD_Rail.__virtual_VDD_Rail
*     - M2.bulk
*     - VDD_Rail.__virtual_VDD_Rail
* Net: GND (width=250nm, material=Tungsten)
*   Connected pins:
*     - M1.bulk
*     - M1.source
*     - M1_Source_Diff.anchor
*     - M1_Source_Diff.__virtual_M1_Source_Diff
*     - M1.source
*     - M1_Bulk_Contact.anchor
*     - M1_Bulk_Contact.__virtual_M1_Bulk_Contact
*     - M1.bulk
*     - M1_Source_Pad.anchor
*     - M1_Source_Pad.__virtual_M1_Source_Pad
*     - M1.source
*     - M1_Bulk_Pad.anchor
*     - M1_Bulk_Pad.__virtual_M1_Bulk_Pad
*     - M1.bulk
*     - GND_Rail.anchor
*     - GND_Rail.__virtual_GND_Rail
*     - M1.source
*     - GND_Rail.__virtual_GND_Rail
*     - M1.bulk
*     - GND_Rail.__virtual_GND_Rail
*     - M1.source
*     - GND_Rail.__virtual_GND_Rail
*     - M1.bulk
*     - GND_Rail.__virtual_GND_Rail
* Net: TEMP_NET (width=250nm, material=Tungsten)

* ========================================
* EXTRACTED DEVICES (Transistors)
* ========================================
MM1 VOUT VIN GND GND NMOS W=1.00u L=1.00u
MM2 VOUT VIN VDD VDD PMOS W=1.00u L=1.00u

* ========================================
* AUTOMATIC STIMULUS & MODELS
* ========================================
Vgnd GND 0 0
.end
