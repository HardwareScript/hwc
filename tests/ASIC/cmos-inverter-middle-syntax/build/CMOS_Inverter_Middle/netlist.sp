* Hardware Script Native Netlist: CMOS_Inverter_Middle
* Generated by hwc v0.1.6 (Syntax Unification)
* Format: SPICE3

* ========================================
* NETS
* ========================================
* Net: GND (pour: INV1_GND_Rail, material: Aluminum, z: 0.0010mm)
* Net: VDD (pour: INV1_VDD_Rail, material: Aluminum, z: 0.0010mm)
* Net: VOUT (pour: INV1_Shared_Drain, material: Aluminum, z: 0.0010mm)
* Net: GND (pour: INV1_NMOS_Source_Pad, material: Aluminum, z: 0.0010mm)
* Net: VDD (pour: INV1_PMOS_Source_Pad, material: Aluminum, z: 0.0010mm)
* Net: GND (pour: INV1_NMOS_Bulk_Pad, material: Aluminum, z: 0.0010mm)
* Net: VDD (pour: INV1_PMOS_Bulk_Pad, material: Aluminum, z: 0.0010mm)
* Net: VIN (width=250nm, material=Tungsten)
*   Connected pins:
*     - INV1.VIN
*     - Via_Gate.via
* Net: VOUT (width=250nm, material=Tungsten)
*   Connected pins:
*     - INV1.VOUT
*     - INV1_Shared_Drain.anchor
*     - INV1_Shared_Drain.__virtual_INV1_Shared_Drain
* Net: VDD (width=250nm, material=Tungsten)
*   Connected pins:
*     - INV1.VDD
*     - INV1_VDD_Rail.anchor
*     - INV1_VDD_Rail.__virtual_INV1_VDD_Rail
*     - INV1_PMOS_Source_Pad.anchor
*     - INV1_PMOS_Source_Pad.__virtual_INV1_PMOS_Source_Pad
*     - INV1_PMOS_Bulk_Pad.anchor
*     - INV1_PMOS_Bulk_Pad.__virtual_INV1_PMOS_Bulk_Pad
*     - Via_PMOS_Source.via
*     - Via_PMOS_Bulk.via
* Net: GND (width=250nm, material=Tungsten)
*   Connected pins:
*     - INV1.GND
*     - INV1_GND_Rail.anchor
*     - INV1_GND_Rail.__virtual_INV1_GND_Rail
*     - INV1_NMOS_Source_Pad.anchor
*     - INV1_NMOS_Source_Pad.__virtual_INV1_NMOS_Source_Pad
*     - INV1_NMOS_Bulk_Pad.anchor
*     - INV1_NMOS_Bulk_Pad.__virtual_INV1_NMOS_Bulk_Pad
*     - Via_NMOS_Source.via
*     - Via_NMOS_Bulk.via

* ========================================
* AUTOMATIC STIMULUS & MODELS
* ========================================
Vgnd GND 0 0
.end
