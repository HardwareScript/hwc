* Hardware Script Native Netlist: Crosstalk_Demo
* Generated by hwc v0.1.6 (Syntax Unification)
* Format: SPICE3

* ========================================
* NETS
* ========================================
* Net: A1 (pour: Pad_A1, material: Aluminum, z: 0.0010mm)
* Net: B1 (pour: Pad_B1, material: Aluminum, z: 0.0010mm)
* Net: A2 (pour: Pad_A2, material: Aluminum, z: 0.0010mm)
* Net: B2 (pour: Pad_B2, material: Aluminum, z: 0.0010mm)
* Net: A1 (width=200000nm, material=Tungsten)
*   Connected pins:
*     - Pad_A1.__virtual_Pad_A1
*     - Pad_A1.__virtual_Pad_A1
*     - Pad_B1.__virtual_Pad_B1
*     - Pad_A1.__virtual_Pad_A1
*     - Pad_B1.__virtual_Pad_B1
* Net: B1 (width=200000nm, material=Tungsten)
*   Connected pins:
*     - Pad_B1.__virtual_Pad_B1
* Net: A2 (width=200000nm, material=Tungsten)
*   Connected pins:
*     - Pad_A2.__virtual_Pad_A2
*     - Pad_A2.__virtual_Pad_A2
*     - Pad_B2.__virtual_Pad_B2
*     - Pad_A2.__virtual_Pad_A2
*     - Pad_B2.__virtual_Pad_B2
* Net: B2 (width=200000nm, material=Tungsten)
*   Connected pins:
*     - Pad_B2.__virtual_Pad_B2
* Net: TEMP_NET (width=200000nm, material=Tungsten)

* ========================================
* AUTOMATIC STIMULUS & MODELS
* ========================================
Vgnd GND 0 0
.end
