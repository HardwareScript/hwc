* Hardware Script Native Netlist: Corner_Demo_mid
* Generated by hwc v0.1.6 (Syntax Unification)
* Format: SPICE3

* ========================================
* NETS
* ========================================
* Net: Edge_A (pour: Pad_Edge_A, material: Aluminum, z: 0.0010mm)
* Net: Edge_B (pour: Pad_Edge_B, material: Aluminum, z: 0.0010mm)
* Net: Tight_A (pour: Pad_Tight_A, material: Aluminum, z: 0.0010mm)
* Net: Tight_B (pour: Pad_Tight_B, material: Aluminum, z: 0.0010mm)
* Net: Edge_A (width=180nm, material=Tungsten)
*   Connected pins:
*     - Pad_Edge_A.__virtual_Pad_Edge_A
*     - Pad_Edge_A.__virtual_Pad_Edge_A
*     - Pad_Edge_B.__virtual_Pad_Edge_B
*     - Pad_Edge_A.__virtual_Pad_Edge_A
*     - Pad_Edge_B.__virtual_Pad_Edge_B
* Net: Edge_B (width=180nm, material=Tungsten)
*   Connected pins:
*     - Pad_Edge_B.__virtual_Pad_Edge_B
* Net: Tight_A (width=180nm, material=Tungsten)
*   Connected pins:
*     - Pad_Tight_A.__virtual_Pad_Tight_A
*     - Pad_Tight_A.__virtual_Pad_Tight_A
*     - Pad_Tight_B.__virtual_Pad_Tight_B
*     - Pad_Tight_A.__virtual_Pad_Tight_A
*     - Pad_Tight_B.__virtual_Pad_Tight_B
* Net: Tight_B (width=180nm, material=Tungsten)
*   Connected pins:
*     - Pad_Tight_B.__virtual_Pad_Tight_B
* Net: TEMP_NET (width=180nm, material=Tungsten)

* ========================================
* AUTOMATIC STIMULUS & MODELS
* ========================================
Vgnd GND 0 0
.end
