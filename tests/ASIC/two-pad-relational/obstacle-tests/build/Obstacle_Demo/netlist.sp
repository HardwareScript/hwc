* Hardware Script Native Netlist: Obstacle_Demo
* Generated by hwc v0.1.6 (Syntax Unification)
* Format: SPICE3

* ========================================
* NETS
* ========================================
* Net: A (pour: Pad_A, material: Aluminum, z: 0.0010mm)
* Net: B (pour: Pad_B, material: Aluminum, z: 0.0010mm)
* Net: A (width=180nm, material=Tungsten)
*   Connected pins:
*     - Pad_A.__virtual_Pad_A
* Net: B (width=180nm, material=Tungsten)
*   Connected pins:
*     - Pad_B.__virtual_Pad_B

* ========================================
* AUTOMATIC STIMULUS & MODELS
* ========================================
Vgnd GND 0 0
.end
