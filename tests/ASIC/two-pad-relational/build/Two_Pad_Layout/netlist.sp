* Hardware Script Native Netlist: Two_Pad_Layout
* Generated by hwc v0.1.6 (Syntax Unification)
* Format: SPICE3

* ========================================
* NETS
* ========================================
* Net: SIG_IN (pour: Pad_A, material: Aluminum, z: 0.0010mm)
* Net: SIG_OUT (pour: Pad_B, material: Aluminum, z: 0.0010mm)
* Net: SIG_IN (width=180nm, material=Tungsten)
*   Connected pins:
*     - Pad_A.__virtual_Pad_A
*     - Pad_A.__virtual_Pad_A
*     - Pad_B.__virtual_Pad_B
*     - Pad_A.__virtual_Pad_A
*     - Pad_B.__virtual_Pad_B
* Net: SIG_OUT (width=180nm, material=Tungsten)
*   Connected pins:
*     - Pad_B.__virtual_Pad_B
* Net: TEMP_NET (width=180nm, material=Tungsten)

* ========================================
* AUTOMATIC STIMULUS & MODELS
* ========================================
Vgnd GND 0 0
.end
