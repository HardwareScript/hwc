* Hardware Script DC Operating Point Test
* Space: Simple_Capacitor_Space
* Generated by hwc v0.1.6
* Format: SPICE3

* ========================================
* NETS
* ========================================
* Net: Out (pour: Bottom_Plate, material: Polysilicon, z: 0.0000mm)
* Net: In (pour: Top_Plate, material: Aluminum, z: 0.0000mm)
* Net: In (pour: In_Pad, material: Aluminum, z: 0.0000mm)
* Net: Out (pour: Out_Pad, material: Polysilicon, z: 0.0000mm)
* Net: In (width=200nm, material=Tungsten)
*   Connected pins:
*     - Top_Plate.anchor
*     - Top_Plate.__virtual_Top_Plate
*     - In_Pad.anchor
*     - In_Pad.__virtual_In_Pad
*     - In_Pad.__virtual_In_Pad
*     - Top_Plate.__virtual_Top_Plate
*     - In_Pad.__virtual_In_Pad
*     - Top_Plate.__virtual_Top_Plate
* Net: Out (width=200nm, material=Tungsten)
*   Connected pins:
*     - Bottom_Plate.anchor
*     - Bottom_Plate.__virtual_Bottom_Plate
*     - Out_Pad.anchor
*     - Out_Pad.__virtual_Out_Pad
*     - Bottom_Plate.__virtual_Bottom_Plate
*     - Out_Pad.__virtual_Out_Pad
*     - Bottom_Plate.__virtual_Bottom_Plate
*     - Out_Pad.__virtual_Out_Pad
* Net: TEMP_NET (width=200nm, material=Tungsten)

* ========================================
* EXTRACTED DEVICES
* ========================================
CC1 In Out 3.45e-13

* ========================================
* STIMULUS & ANALYSIS
* ========================================
Vgnd GND 0 0
.op
.end
