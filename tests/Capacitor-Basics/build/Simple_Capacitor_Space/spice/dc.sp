* Hardware Script DC Operating Point Test
* Space: Simple_Capacitor_Space
* Generated by hwc v0.3.1
* Format: SPICE3

.include "circuit.sp"

* ========================================
* STIMULUS & ANALYSIS
* ========================================
V_In In 0 DC 1.8000e0
V_GND GND 0 DC 0.0000e0
I_load_Out Out 0 DC 1.0000e-9
.op
.end
