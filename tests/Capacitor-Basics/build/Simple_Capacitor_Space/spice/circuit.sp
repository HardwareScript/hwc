* Hardware Script Pure Circuit (DUT)
* Space: Simple_Capacitor_Space
* Generated by hwc v0.2.1
* Format: SPICE3

* ========================================
* PDK SUBCIRCUIT: sky130_fd_pr__cap_mim
* ========================================
* Subcircuit 'sky130_fd_pr__cap_mim' uses foundry model
.include "sky130_fd_pr/models/sky130_fd_pr__cap_mim.model.spice"

* ========================================
* NETS
* ========================================
* Net: Out (pour: Bottom_Plate, material: Aluminum, z: 0nm)
* Net: In (pour: Top_Plate, material: MIMCap, z: 25nm)
* Net: In (pour: Top_Contact_Metal2, material: Aluminum, z: 70nm)
* Net: Out (pour: Out_Pad, material: Aluminum, z: 0nm)
* Net: In (pour: In_Pad, material: Aluminum, z: 70nm)
* Net: In (width=200nm, material=Tungsten)
*   Connected pins:
*     - Top_Plate.anchor
*     - Top_Plate.__virtual_Top_Plate
*     - Top_Contact_Metal2.anchor
*     - Top_Contact_Metal2.__virtual_Top_Contact_Metal2
*     - Via_Top.__virtual_Via_Top
*     - In_Pad.anchor
*     - In_Pad.__virtual_In_Pad
* Net: Out (width=200nm, material=Tungsten)
*   Connected pins:
*     - Bottom_Plate.anchor
*     - Bottom_Plate.__virtual_Bottom_Plate
*     - Out_Pad.anchor
*     - Out_Pad.__virtual_Out_Pad

* ========================================
* EXTRACTED DEVICES
* ========================================
XC1 In Out sky130_fd_pr__cap_mim W=11.00u L=11.00u

* ========================================
* INTEGRATED TRACE PARASITICS
* ========================================
* Trace resistance
RRtr_In_0 nIn_entry In 1.786000e1
* Ground capacitance
CCgnd_In_0 In GND 5.467461e-15
* Trace resistance
RRtr_Out_0 nOut_entry Out 2.679000e1

* Total parasitic elements: 3

.end
