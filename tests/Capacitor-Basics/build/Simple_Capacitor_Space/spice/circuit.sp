* Hardware Script Pure Circuit (DUT)
* Space: Simple_Capacitor_Space
* Generated by hwc v0.2.1
* Format: SPICE3

* ========================================
* PDK SUBCIRCUIT: sky130_fd_pr__cap_mim_m3_1
* ========================================
* Subcircuit 'sky130_fd_pr__cap_mim_m3_1' uses foundry model
.include "sky130_fd_pr/models/sky130_fd_pr__cap_mim_m3_1.model.spice"

* ========================================
* NETS
* ========================================
* Net: Out (pour: Bottom_Plate, material: Aluminum, z: 1.32µm)
* Net: In (pour: Top_Plate, material: CAPM, z: 2.17µm)
* Net: GND (pour: Bulk_Tie, material: Aluminum, z: 250nm)
* Net: In (pour: Top_Contact_Metal4, material: Aluminum, z: 2.42µm)
* Net: Out (pour: Out_Pad, material: Aluminum, z: 1.32µm)
* Net: In (pour: In_Pad, material: Aluminum, z: 2.42µm)
* Net: In (width=300nm, material=Tungsten)
*   Connected pins:
*     - Top_Plate.anchor
*     - Top_Plate.__virtual_Top_Plate
*     - Top_Contact_Metal4.anchor
*     - Top_Contact_Metal4.__virtual_Top_Contact_Metal4
*     - Via_Top_CAPM.__virtual_Via_Top_CAPM
*     - In_Pad.anchor
*     - In_Pad.__virtual_In_Pad
* Net: Out (width=300nm, material=Tungsten)
*   Connected pins:
*     - Bottom_Plate.anchor
*     - Bottom_Plate.__virtual_Bottom_Plate
*     - Out_Pad.anchor
*     - Out_Pad.__virtual_Out_Pad
* Net: GND (width=200000nm, material=Tungsten)
*   Connected pins:
*     - Bulk_Tie.anchor
*     - Bulk_Tie.__virtual_Bulk_Tie

* ========================================
* EXTRACTED DEVICES
* ========================================
XC1 In Out GND sky130_fd_pr__cap_mim_m3_1 W=10.00u L=10.00u

* ========================================
* INTEGRATED TRACE PARASITICS
* ========================================
* Trace resistance
RRtr_In_0 nIn_entry In 5.339645e-1
* Ground capacitance
CCgnd_In_0 In GND 3.315008e-16
* Trace resistance
RRtr_Out_0 nOut_entry Out 3.337278e-1
* Ground capacitance
CCgnd_Out_0 Out GND 2.071880e-16

* Total parasitic elements: 4

.end
