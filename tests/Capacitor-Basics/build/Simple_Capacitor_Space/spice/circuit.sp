* Hardware Script Pure Circuit (DUT)
* Space: Simple_Capacitor_Space
* Generated by hwc v0.2.1
* Format: SPICE3

* ========================================
* NETS
* ========================================
* Net: Out (pour: Bottom_Plate, material: Aluminum, z: 1.32µm)
* Net: In (pour: Top_Plate, material: CAPM, z: 2.17µm)
* Net: In (pour: Top_Contact_Metal4, material: Aluminum, z: 2.42µm)
* Net: Out (pour: Out_Pad, material: Aluminum, z: 1.32µm)
* Net: In (pour: In_Pad, material: Aluminum, z: 2.42µm)
* Net: In (width=300nm, material=Aluminum)
*   Connected pins:
*     - Top_Plate.anchor
*     - Top_Plate.__virtual_Top_Plate
*     - Top_Contact_Metal4.anchor
*     - Top_Contact_Metal4.__virtual_Top_Contact_Metal4
*     - In_Pad.anchor
*     - In_Pad.__virtual_In_Pad
*     - Via_Top_CAPM.__virtual_Via_Top_CAPM
* Net: Out (width=300nm, material=Aluminum)
*   Connected pins:
*     - Bottom_Plate.anchor
*     - Bottom_Plate.__virtual_Bottom_Plate
*     - Out_Pad.anchor
*     - Out_Pad.__virtual_Out_Pad
* Net: GND (width=300nm, material=Aluminum)

* ========================================
* EXTRACTED DEVICES
* ========================================
XC1 nIn_capm nOut_metal3_tr0_end GND Capacitor L=10.00u W=10.00u

* ========================================
* INTEGRATED TRACE PARASITICS
* ========================================
* Via/Contact resistance
Rvia_In_capm_metal4 nIn_metal4 nIn_capm 3.460208e1
* Trace resistance
Rtr_Out_0_0 Out nOut_metal3_tr0_end 5.562130e-2
* Ground capacitance
Cgnd_Out_0_0 nOut_metal3_tr0_end GND 3.453133e-17
* Trace resistance
Rtr_In_1_0 nIn_metal4 In 4.783432e-1
* Ground capacitance
Cgnd_In_1_0 In GND 2.969695e-16
* Ground capacitance
Cgnd_pour_Bottom_Plate nOut_metal3_tr0_end GND 2.785527e-14
* Ground capacitance
Cgnd_pour_Top_Plate nIn_capm GND 6.906266e-13
* Ground capacitance
Cgnd_pour_Top_Contact_Metal4 nIn_metal4 GND 3.683342e-17
* Ground capacitance
Cgnd_pour_Out_Pad Out GND 9.208355e-16
* Ground capacitance
Cgnd_pour_In_Pad In GND 9.208355e-16

* Total parasitic elements: 10

.end
