* Hardware Script Transient Waveform Test
* Space: Simple_Capacitor_Space
* Generated by hwc v0.2.1
* Format: SPICE3

.include "circuit.sp"

* ========================================
* STIMULUS & ANALYSIS
* ========================================
V_In nIn_entry 0 DC 1.800
.tran 200ns
.end
