* Hardware Script Native Netlist: SoC_Topological_Sort
* Generated by hwc v0.1.6 (Syntax Unification)
* Format: SPICE3

* ========================================
* NETS
* ========================================
* Net: VDD (pour: Supply_Rail, material: Copper, z: 0.0000mm)

* ========================================
* COMPONENTS
* ========================================
XGate_A nc_0 nc_1 Gate
XGate_B nc_2 nc_3 Gate
XGate_C nc_4 nc_5 Gate
XPower_Reg nc_6 nc_7 Gate
XSupply_Rail VDD Pour(Copper)
XChain_1 nc_9 nc_10 Gate
XChain_2 nc_11 nc_12 Gate
XChain_3 nc_13 nc_14 Gate
XChain_4 nc_15 nc_16 Gate

.end
