* Hardware Script Native Netlist: Test16BitChained
* Generated by hwc v0.1.6 (Syntax Unification)
* Format: SPICE3

* ========================================
* COMPONENTS
* ========================================
XAdder[0] nc_0 nc_1 nc_2 nc_3 nc_4 Adder
XAdder[1] nc_5 nc_6 nc_7 nc_8 nc_9 Adder
XAdder[2] nc_10 nc_11 nc_12 nc_13 nc_14 Adder
XAdder[3] nc_15 nc_16 nc_17 nc_18 nc_19 Adder
XAdder[4] nc_20 nc_21 nc_22 nc_23 nc_24 Adder
XAdder[5] nc_25 nc_26 nc_27 nc_28 nc_29 Adder
XAdder[6] nc_30 nc_31 nc_32 nc_33 nc_34 Adder
XAdder[7] nc_35 nc_36 nc_37 nc_38 nc_39 Adder
XAdder[8] nc_40 nc_41 nc_42 nc_43 nc_44 Adder
XAdder[9] nc_45 nc_46 nc_47 nc_48 nc_49 Adder
XAdder[10] nc_50 nc_51 nc_52 nc_53 nc_54 Adder
XAdder[11] nc_55 nc_56 nc_57 nc_58 nc_59 Adder
XAdder[12] nc_60 nc_61 nc_62 nc_63 nc_64 Adder
XAdder[13] nc_65 nc_66 nc_67 nc_68 nc_69 Adder
XAdder[14] nc_70 nc_71 nc_72 nc_73 nc_74 Adder
XAdder[15] nc_75 nc_76 nc_77 nc_78 nc_79 Adder

* ========================================
* DEVICE EXTRACTION REQUIRES EXPLICIT BINDINGS
* Use 'device: DeviceName.terminal' property
* ========================================

.end
