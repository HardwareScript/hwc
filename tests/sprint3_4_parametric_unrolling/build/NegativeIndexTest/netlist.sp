* Hardware Script Native Netlist: NegativeIndexTest
* Generated by hwc v0.1.6 (Syntax Unification)
* Format: SPICE3

* ========================================
* NETS
* ========================================
* Net: D[-5] (pour: Test_0, material: Copper, layer: 1)
* Net: D[-4] (pour: Test_1, material: Copper, layer: 1)
* Net: D[-3] (pour: Test_2, material: Copper, layer: 1)
* Net: D[-2] (pour: Test_3, material: Copper, layer: 1)
* Net: D[-5] (width=100000nm, material=Copper)
* Net: D[-4] (width=100000nm, material=Copper)
* Net: D[-3] (width=100000nm, material=Copper)

* ========================================
* COMPONENTS
* ========================================
XTest_0 D[-5] Pour(Copper)
XTest_1 D[-4] Pour(Copper)
XTest_2 D[-3] Pour(Copper)
XTest_3 D[-2] Pour(Copper)

* ========================================
* DEVICE EXTRACTION REQUIRES EXPLICIT BINDINGS
* Use 'device: DeviceName.terminal' property
* ========================================

.end
