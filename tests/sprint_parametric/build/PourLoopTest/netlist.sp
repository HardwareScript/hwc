* Hardware Script Native Netlist: PourLoopTest
* Generated by hwc v0.1.6 (Syntax Unification)
* Format: SPICE3

* ========================================
* NETS
* ========================================
* Net: Bus[0] (pour: Trace[0], material: Copper, layer: 3)
* Net: Bus[1] (pour: Trace[1], material: Copper, layer: 4)
* Net: Bus[2] (pour: Trace[2], material: Copper, layer: 5)
* Net: Bus[3] (pour: Trace[3], material: Copper, layer: 6)
* Net: Bus[0] (width=100000nm, material=Copper)
* Net: Bus[1] (width=100000nm, material=Copper)
* Net: Bus[2] (width=100000nm, material=Copper)
* Net: Bus[3] (width=100000nm, material=Copper)
* Net: Bus[0] (width=100000nm, material=Copper)
* Net: Bus[0] (width=100000nm, material=Copper)
* Net: Bus[1] (width=100000nm, material=Copper)
* Net: Bus[1] (width=100000nm, material=Copper)
* Net: Bus[2] (width=100000nm, material=Copper)
* Net: Bus[2] (width=100000nm, material=Copper)
* Net: Bus[3] (width=100000nm, material=Copper)

* ========================================
* COMPONENTS
* ========================================
XTrace[0] Bus[0] Pour(Copper)
XTrace[1] Bus[1] Pour(Copper)
XTrace[2] Bus[2] Pour(Copper)
XTrace[3] Bus[3] Pour(Copper)
XVia[0] Bus[0] Contact(Copper)
XVia[1] Bus[1] Contact(Copper)
XVia[2] Bus[2] Contact(Copper)
XVia[3] Bus[3] Contact(Copper)

* ========================================
* DEVICE EXTRACTION REQUIRES EXPLICIT BINDINGS
* Use 'device: DeviceName.terminal' property
* ========================================

.end
