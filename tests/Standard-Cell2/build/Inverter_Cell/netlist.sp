* Hardware Script Native Netlist: Inverter_Cell
* Generated by hwc v0.1.6 (Syntax Unification)
* Format: SPICE3

* ========================================
* NETS
* ========================================
* Net: VDD (pour: VDD_Rail, material: Aluminum, z: 0.0009mm)
* Net: GND (pour: GND_Rail, material: Aluminum, z: 0.0009mm)
* Net: VDD (pour: PMOS_Source, material: Silicon_N, z: 0.0001mm)
* Net: Out (pour: PMOS_Drain, material: Silicon_N, z: 0.0001mm)
* Net: GND (pour: NMOS_Source, material: Silicon_P, z: 0.0001mm)
* Net: Out (pour: NMOS_Drain, material: Silicon_P, z: 0.0001mm)
* Net: In (pour: Gate_Vertical, material: Polysilicon, z: 0.0003mm)
* Net: In (pour: Gate_Horizontal, material: Polysilicon, z: 0.0003mm)
* Net: In (pour: Gate_Pad, material: Polysilicon, z: 0.0003mm)
* Net: VDD (pour: M1_PMOS_Source, material: Aluminum, z: 0.0009mm)
* Net: GND (pour: M1_NMOS_Source, material: Aluminum, z: 0.0009mm)
* Net: Out (pour: M1_Drain_Tie, material: Aluminum, z: 0.0009mm)
* Net: Out (pour: M1_Out_Pin, material: Aluminum, z: 0.0009mm)
* Net: In (pour: M1_In_Pad, material: Aluminum, z: 0.0009mm)
* Net: In (width=180nm, material=Tungsten)
*   Connected pins:
*     - Gate_Vertical.anchor
*     - Gate_Vertical.__virtual_Gate_Vertical
*     - Gate_Horizontal.anchor
*     - Gate_Horizontal.__virtual_Gate_Horizontal
*     - Gate_Pad.anchor
*     - Gate_Pad.__virtual_Gate_Pad
*     - M1_In_Pad.anchor
*     - M1_In_Pad.__virtual_M1_In_Pad
*     - Via_In.via
* Net: Out (width=180nm, material=Tungsten)
*   Connected pins:
*     - PMOS_Drain.anchor
*     - PMOS_Drain.__virtual_PMOS_Drain
*     - NMOS_Drain.anchor
*     - NMOS_Drain.__virtual_NMOS_Drain
*     - M1_Drain_Tie.anchor
*     - M1_Drain_Tie.__virtual_M1_Drain_Tie
*     - M1_Out_Pin.anchor
*     - M1_Out_Pin.__virtual_M1_Out_Pin
*     - Via_ND.via
*     - Via_PD1.via
*     - Via_PD2.via
* Net: VDD (width=180nm, material=Tungsten)
*   Connected pins:
*     - VDD_Rail.anchor
*     - VDD_Rail.__virtual_VDD_Rail
*     - PMOS_Source.anchor
*     - PMOS_Source.__virtual_PMOS_Source
*     - M1_PMOS_Source.anchor
*     - M1_PMOS_Source.__virtual_M1_PMOS_Source
*     - Via_PS1.via
*     - Via_PS2.via
* Net: GND (width=180nm, material=Tungsten)
*   Connected pins:
*     - GND_Rail.anchor
*     - GND_Rail.__virtual_GND_Rail
*     - NMOS_Source.anchor
*     - NMOS_Source.__virtual_NMOS_Source
*     - M1_NMOS_Source.anchor
*     - M1_NMOS_Source.__virtual_M1_NMOS_Source
*     - Via_NS.via

* ========================================
* AUTOMATIC STIMULUS & MODELS
* ========================================
Vgnd GND 0 0
.end
