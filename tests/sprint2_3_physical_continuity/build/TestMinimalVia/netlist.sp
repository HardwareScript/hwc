* Hardware Script Native Netlist: TestMinimalVia
* Generated by hwc v0.1.6 (Syntax Unification)
* Format: SPICE3

* ========================================
* NETS
* ========================================
* Net: VCC (pour: Bottom, material: Copper, layer: 1)
* Net: VCC (pour: Top, material: Copper, layer: 3)

* ========================================
* COMPONENTS
* ========================================
XBottom VCC Pour(Copper)
XTop VCC Pour(Copper)
XVia VCC Contact(Copper)

.end
