* Hardware Script Native Netlist: TestP43SimpleComponent
* Generated by hwc v0.1.6 (Syntax Unification)
* Format: SPICE3

* ========================================
* NETS
* ========================================
* Net: VCC (pour: VCCPour, material: Copper, layer: 2)
* Net: GND (pour: GNDPour, material: Copper, layer: 2)
* Net: VCC (width=100000nm, material=Copper)

* ========================================
* COMPONENTS
* ========================================
XVCCPour VCC Pour(Copper)
XGNDPour GND Pour(Copper)
XR1 nc_2 nc_3 SimpleResistor

* ========================================
* EXTRACTED DEVICES (Transistors)
* ========================================
MR1 0 0 0 0 SimpleResistor W=1.00u L=1.00u

.end
