* Hardware Script Native Netlist: ZAxisSemanticSpace
* Generated by hwc v0.1.6 (Syntax Unification)
* Format: SPICE3

* ========================================
* NETS
* ========================================
* Net: VDD (pour: TopPlane, material: Copper, z: 0.0002mm)
* Net: VDD (pour: BottomPlane, material: Copper, z: 0.0000mm)

* ========================================
* COMPONENTS
* ========================================
XTopPlane VDD Pour(Copper)
XBottomPlane VDD Pour(Copper)
XStackVia VDD Contact(Copper)

.end
