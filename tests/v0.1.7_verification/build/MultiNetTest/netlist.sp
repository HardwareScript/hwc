* Hardware Script Native Netlist: MultiNetTest
* Generated by hwc v0.1.6 (Syntax Unification)
* Format: SPICE3

* ========================================
* NETS
* ========================================
* Net: DATA (pour: DATA1_Pad_Copper, material: Copper, z: 1.2700mm)
* Net: DATA (pour: DATA2_Pad_Copper, material: Copper, z: 1.2700mm)
* Net: CLK (pour: CLK1_Pad_Copper, material: Copper, z: 1.2700mm)
* Net: CLK (pour: CLK2_Pad_Copper, material: Copper, z: 1.2700mm)
* Net: GND (pour: GND1_Pad_Copper, material: Copper, z: 1.2700mm)
* Net: GND (pour: GND2_Pad_Copper, material: Copper, z: 1.2700mm)
* Net: VCC (pour: VCC1_Pad_Copper, material: Copper, z: 1.2700mm)
* Net: VCC (pour: VCC2_Pad_Copper, material: Copper, z: 1.2700mm)
* Net: USB_DP (pour: UDP1_Pad_Copper, material: Copper, z: 1.2700mm)
* Net: USB_DP (pour: UDP2_Pad_Copper, material: Copper, z: 1.2700mm)
* Net: USB_DM (pour: UDM1_Pad_Copper, material: Copper, z: 1.2700mm)
* Net: USB_DM (pour: UDM2_Pad_Copper, material: Copper, z: 1.2700mm)
* Net: DATA (width=200000nm, material=FR4)
* Net: CLK (width=200000nm, material=FR4)
*   Connected pins:
*     - DATA1.p
*     - DATA2.p
*     - DATA1.p
*     - DATA2.p
* Net: GND (width=200000nm, material=FR4)
*   Connected pins:
*     - CLK1.p
*     - CLK2.p
*     - CLK1.p
*     - CLK2.p
* Net: VCC (width=200000nm, material=FR4)
*   Connected pins:
*     - GND1.p
*     - GND2.p
*     - GND1.p
*     - GND2.p
* Net: USB_DP (width=200000nm, material=FR4)
*   Connected pins:
*     - VCC1.p
*     - VCC2.p
*     - VCC1.p
*     - VCC2.p
* Net: USB_DM (width=200000nm, material=FR4)
*   Connected pins:
*     - UDP1.p
*     - UDP2.p
*     - UDP1.p
*     - UDP2.p

* ========================================
* COMPONENTS
* ========================================
XDATA1 DATA Pad
XDATA1_Pad_Copper DATA Pour(Copper)
XDATA2 DATA Pad
XDATA2_Pad_Copper DATA Pour(Copper)
XCLK1 CLK Pad
XCLK1_Pad_Copper CLK Pour(Copper)
XCLK2 CLK Pad
XCLK2_Pad_Copper CLK Pour(Copper)
XGND1 GND Pad
XGND1_Pad_Copper GND Pour(Copper)
XGND2 GND Pad
XGND2_Pad_Copper GND Pour(Copper)
XVCC1 VCC Pad
XVCC1_Pad_Copper VCC Pour(Copper)
XVCC2 VCC Pad
XVCC2_Pad_Copper VCC Pour(Copper)
XUDP1 USB_DP Pad
XUDP1_Pad_Copper USB_DP Pour(Copper)
XUDP2 USB_DP Pad
XUDP2_Pad_Copper USB_DP Pour(Copper)
XUDM1 USB_DM Pad
XUDM1_Pad_Copper USB_DM Pour(Copper)
XUDM2 USB_DM Pad
XUDM2_Pad_Copper USB_DM Pour(Copper)

* ========================================
* DEVICE EXTRACTION REQUIRES EXPLICIT BINDINGS
* Use 'device: DeviceName.terminal' property
* ========================================

.end
