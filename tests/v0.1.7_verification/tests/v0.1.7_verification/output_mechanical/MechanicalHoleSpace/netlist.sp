* Hardware Script Native Netlist: MechanicalHoleSpace
* Generated by hwc v0.1.6 (Syntax Unification)
* Format: SPICE3

.end
