* Hardware Script Native Netlist: VerificationSpace
* Generated by hwc v0.1.6 (Syntax Unification)
* Format: SPICE3

* ========================================
* NETS
* ========================================
* Net: AutoNet (pour: PourA, material: Copper, layer: 1)
* Net: AutoNet (pour: PourB, material: Copper, layer: 2)
* Net: AutoNet (width=100000nm, material=Copper)

* ========================================
* COMPONENTS
* ========================================
XPourA AutoNet Pour(Copper)
XPourB AutoNet Pour(Copper)
XLargePad ManualNet Contact(Copper)
XManualVia ManualNet Contact(Copper)
XAutoVia_AutoNet_1_2 AutoNet Contact(Copper)

.end
