* Hardware Script Native Netlist: ProceduralTest
* Generated by hwc v0.1.6 (Syntax Unification)
* Format: SPICE3

* ========================================
* NETS
* ========================================
* Net: OUT (width=200000nm, material=TO220)
* Net: GND (width=200000nm, material=TO220)
*   Connected pins:
*     - U1.Pin3

* ========================================
* COMPONENTS
* ========================================
XU1 GND VCC OUT TO220

* ========================================
* DEVICE EXTRACTION REQUIRES EXPLICIT BINDINGS
* Use 'device: DeviceName.terminal' property
* ========================================

.end
