* Hardware Script Native Netlist: LineOfSight
* Generated by hwc v0.1.6 (Syntax Unification)
* Format: SPICE3

* ========================================
* NETS
* ========================================

* ========================================
* COMPONENTS
* ========================================
XC1 NET_C1_P1_to_C2_P1 nc_1 Connector
XC2 NET_C1_P1_to_C2_P1 nc_3 Connector

* ========================================
* DEVICE EXTRACTION REQUIRES EXPLICIT BINDINGS
* Use 'device: DeviceName.terminal' property
* ========================================

.end
