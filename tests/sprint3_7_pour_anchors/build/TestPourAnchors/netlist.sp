* Hardware Script Native Netlist: TestPourAnchors
* Generated by hwc v0.1.6 (Syntax Unification)
* Format: SPICE3

* ========================================
* NETS
* ========================================
* Net: GND (pour: GroundPlane, material: Copper, layer: 1)

* ========================================
* COMPONENTS
* ========================================
XGroundPlane GND Pour(Copper)
XBlock_Right nc_1 nc_2 TestBlock
XBlock_Left nc_3 nc_4 TestBlock
XBlock_Top nc_5 nc_6 TestBlock
XBlock_Bottom nc_7 nc_8 TestBlock

* ========================================
* DEVICE EXTRACTION REQUIRES EXPLICIT BINDINGS
* Use 'device: DeviceName.terminal' property
* ========================================

.end
