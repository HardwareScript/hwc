* Hardware Script Native Netlist: TestMixedAnchors
* Generated by hwc v0.1.6 (Syntax Unification)
* Format: SPICE3

* ========================================
* NETS
* ========================================
* Net: GND (pour: GroundPlane1, material: Copper, layer: 1)
* Net: VDD (pour: PowerPlane1, material: Copper, layer: 1)
* Net: GND (width=100000nm, material=Copper)

* ========================================
* COMPONENTS
* ========================================
XGroundPlane1 GND Pour(Copper)
XPowerPlane1 VDD Pour(Copper)
XIC1 nc_2 nc_3 nc_4 nc_5 ICPackage
XIC2 nc_6 nc_7 nc_8 nc_9 ICPackage
XIC3 nc_10 nc_11 nc_12 nc_13 ICPackage

* ========================================
* DEVICE EXTRACTION REQUIRES EXPLICIT BINDINGS
* Use 'device: DeviceName.terminal' property
* ========================================

.end
