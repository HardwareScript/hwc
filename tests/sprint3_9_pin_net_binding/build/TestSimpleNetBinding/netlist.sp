* Hardware Script Native Netlist: TestSimpleNetBinding
* Generated by hwc v0.1.6 (Syntax Unification)
* Format: SPICE3

* ========================================
* NETS
* ========================================
* Net: CarryIn (width=100000nm, material=FullAdder)
* Net: OutputSum (width=100000nm, material=FullAdder)
* Net: InputA (width=100000nm, material=FullAdder)
* Net: CarryOut (width=100000nm, material=FullAdder)

* ========================================
* COMPONENTS
* ========================================
XAdder0 InputA InputB CarryIn OutputSum CarryOut FullAdder

* ========================================
* DEVICE EXTRACTION REQUIRES EXPLICIT BINDINGS
* Use 'device: DeviceName.terminal' property
* ========================================

.end
