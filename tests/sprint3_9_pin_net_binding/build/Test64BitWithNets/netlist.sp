* Hardware Script Native Netlist: Test64BitWithNets
* Generated by hwc v0.1.6 (Syntax Unification)
* Format: SPICE3

* ========================================
* NETS
* ========================================
* Net: Carry[0] (width=100000nm, material=FullAdder)
* Net: Sum[0] (width=100000nm, material=FullAdder)
* Net: A[0] (width=100000nm, material=FullAdder)
* Net: Carry[1] (width=100000nm, material=FullAdder)
* Net: B[0] (width=100000nm, material=FullAdder)
*   Connected pins:
*     - Adder[1].carry_in
* Net: Sum[1] (width=100000nm, material=FullAdder)
* Net: A[1] (width=100000nm, material=FullAdder)
* Net: Carry[2] (width=100000nm, material=FullAdder)
* Net: B[1] (width=100000nm, material=FullAdder)
*   Connected pins:
*     - Adder[2].carry_in
* Net: Sum[2] (width=100000nm, material=FullAdder)
* Net: A[2] (width=100000nm, material=FullAdder)
* Net: Carry[3] (width=100000nm, material=FullAdder)
* Net: B[2] (width=100000nm, material=FullAdder)
*   Connected pins:
*     - Adder[3].carry_in
* Net: Sum[3] (width=100000nm, material=FullAdder)
* Net: A[3] (width=100000nm, material=FullAdder)
* Net: Carry[4] (width=100000nm, material=FullAdder)
* Net: B[3] (width=100000nm, material=FullAdder)
*   Connected pins:
*     - Adder[4].carry_in
* Net: Sum[4] (width=100000nm, material=FullAdder)
* Net: A[4] (width=100000nm, material=FullAdder)
* Net: Carry[5] (width=100000nm, material=FullAdder)
* Net: B[4] (width=100000nm, material=FullAdder)
*   Connected pins:
*     - Adder[5].carry_in
* Net: Sum[5] (width=100000nm, material=FullAdder)
* Net: A[5] (width=100000nm, material=FullAdder)
* Net: Carry[6] (width=100000nm, material=FullAdder)
* Net: B[5] (width=100000nm, material=FullAdder)
*   Connected pins:
*     - Adder[6].carry_in
* Net: Sum[6] (width=100000nm, material=FullAdder)
* Net: A[6] (width=100000nm, material=FullAdder)
* Net: Carry[7] (width=100000nm, material=FullAdder)
* Net: B[6] (width=100000nm, material=FullAdder)
*   Connected pins:
*     - Adder[7].carry_in
* Net: Sum[7] (width=100000nm, material=FullAdder)
* Net: A[7] (width=100000nm, material=FullAdder)
* Net: Carry[8] (width=100000nm, material=FullAdder)
* Net: B[7] (width=100000nm, material=FullAdder)
*   Connected pins:
*     - Adder[8].carry_in
* Net: Sum[8] (width=100000nm, material=FullAdder)
* Net: A[8] (width=100000nm, material=FullAdder)
* Net: Carry[9] (width=100000nm, material=FullAdder)
* Net: B[8] (width=100000nm, material=FullAdder)
*   Connected pins:
*     - Adder[9].carry_in
* Net: Sum[9] (width=100000nm, material=FullAdder)
* Net: A[9] (width=100000nm, material=FullAdder)
* Net: Carry[10] (width=100000nm, material=FullAdder)
* Net: B[9] (width=100000nm, material=FullAdder)
*   Connected pins:
*     - Adder[10].carry_in
* Net: Sum[10] (width=100000nm, material=FullAdder)
* Net: A[10] (width=100000nm, material=FullAdder)
* Net: Carry[11] (width=100000nm, material=FullAdder)
* Net: B[10] (width=100000nm, material=FullAdder)
*   Connected pins:
*     - Adder[11].carry_in
* Net: Sum[11] (width=100000nm, material=FullAdder)
* Net: A[11] (width=100000nm, material=FullAdder)
* Net: Carry[12] (width=100000nm, material=FullAdder)
* Net: B[11] (width=100000nm, material=FullAdder)
*   Connected pins:
*     - Adder[12].carry_in
* Net: Sum[12] (width=100000nm, material=FullAdder)
* Net: A[12] (width=100000nm, material=FullAdder)
* Net: Carry[13] (width=100000nm, material=FullAdder)
* Net: B[12] (width=100000nm, material=FullAdder)
*   Connected pins:
*     - Adder[13].carry_in
* Net: Sum[13] (width=100000nm, material=FullAdder)
* Net: A[13] (width=100000nm, material=FullAdder)
* Net: Carry[14] (width=100000nm, material=FullAdder)
* Net: B[13] (width=100000nm, material=FullAdder)
*   Connected pins:
*     - Adder[14].carry_in
* Net: Sum[14] (width=100000nm, material=FullAdder)
* Net: A[14] (width=100000nm, material=FullAdder)
* Net: Carry[15] (width=100000nm, material=FullAdder)
* Net: B[14] (width=100000nm, material=FullAdder)
*   Connected pins:
*     - Adder[15].carry_in
* Net: Sum[15] (width=100000nm, material=FullAdder)
* Net: A[15] (width=100000nm, material=FullAdder)
* Net: Carry[16] (width=100000nm, material=FullAdder)
* Net: B[15] (width=100000nm, material=FullAdder)
*   Connected pins:
*     - Adder[16].carry_in
* Net: Sum[16] (width=100000nm, material=FullAdder)
* Net: A[16] (width=100000nm, material=FullAdder)
* Net: Carry[17] (width=100000nm, material=FullAdder)
* Net: B[16] (width=100000nm, material=FullAdder)
*   Connected pins:
*     - Adder[17].carry_in
* Net: Sum[17] (width=100000nm, material=FullAdder)
* Net: A[17] (width=100000nm, material=FullAdder)
* Net: Carry[18] (width=100000nm, material=FullAdder)
* Net: B[17] (width=100000nm, material=FullAdder)
*   Connected pins:
*     - Adder[18].carry_in
* Net: Sum[18] (width=100000nm, material=FullAdder)
* Net: A[18] (width=100000nm, material=FullAdder)
* Net: Carry[19] (width=100000nm, material=FullAdder)
* Net: B[18] (width=100000nm, material=FullAdder)
*   Connected pins:
*     - Adder[19].carry_in
* Net: Sum[19] (width=100000nm, material=FullAdder)
* Net: A[19] (width=100000nm, material=FullAdder)
* Net: Carry[20] (width=100000nm, material=FullAdder)
* Net: B[19] (width=100000nm, material=FullAdder)
*   Connected pins:
*     - Adder[20].carry_in
* Net: Sum[20] (width=100000nm, material=FullAdder)
* Net: A[20] (width=100000nm, material=FullAdder)
* Net: Carry[21] (width=100000nm, material=FullAdder)
* Net: B[20] (width=100000nm, material=FullAdder)
*   Connected pins:
*     - Adder[21].carry_in
* Net: Sum[21] (width=100000nm, material=FullAdder)
* Net: A[21] (width=100000nm, material=FullAdder)
* Net: Carry[22] (width=100000nm, material=FullAdder)
* Net: B[21] (width=100000nm, material=FullAdder)
*   Connected pins:
*     - Adder[22].carry_in
* Net: Sum[22] (width=100000nm, material=FullAdder)
* Net: A[22] (width=100000nm, material=FullAdder)
* Net: Carry[23] (width=100000nm, material=FullAdder)
* Net: B[22] (width=100000nm, material=FullAdder)
*   Connected pins:
*     - Adder[23].carry_in
* Net: Sum[23] (width=100000nm, material=FullAdder)
* Net: A[23] (width=100000nm, material=FullAdder)
* Net: Carry[24] (width=100000nm, material=FullAdder)
* Net: B[23] (width=100000nm, material=FullAdder)
*   Connected pins:
*     - Adder[24].carry_in
* Net: Sum[24] (width=100000nm, material=FullAdder)
* Net: A[24] (width=100000nm, material=FullAdder)
* Net: Carry[25] (width=100000nm, material=FullAdder)
* Net: B[24] (width=100000nm, material=FullAdder)
*   Connected pins:
*     - Adder[25].carry_in
* Net: Sum[25] (width=100000nm, material=FullAdder)
* Net: A[25] (width=100000nm, material=FullAdder)
* Net: Carry[26] (width=100000nm, material=FullAdder)
* Net: B[25] (width=100000nm, material=FullAdder)
*   Connected pins:
*     - Adder[26].carry_in
* Net: Sum[26] (width=100000nm, material=FullAdder)
* Net: A[26] (width=100000nm, material=FullAdder)
* Net: Carry[27] (width=100000nm, material=FullAdder)
* Net: B[26] (width=100000nm, material=FullAdder)
*   Connected pins:
*     - Adder[27].carry_in
* Net: Sum[27] (width=100000nm, material=FullAdder)
* Net: A[27] (width=100000nm, material=FullAdder)
* Net: Carry[28] (width=100000nm, material=FullAdder)
* Net: B[27] (width=100000nm, material=FullAdder)
*   Connected pins:
*     - Adder[28].carry_in
* Net: Sum[28] (width=100000nm, material=FullAdder)
* Net: A[28] (width=100000nm, material=FullAdder)
* Net: Carry[29] (width=100000nm, material=FullAdder)
* Net: B[28] (width=100000nm, material=FullAdder)
*   Connected pins:
*     - Adder[29].carry_in
* Net: Sum[29] (width=100000nm, material=FullAdder)
* Net: A[29] (width=100000nm, material=FullAdder)
* Net: Carry[30] (width=100000nm, material=FullAdder)
* Net: B[29] (width=100000nm, material=FullAdder)
*   Connected pins:
*     - Adder[30].carry_in
* Net: Sum[30] (width=100000nm, material=FullAdder)
* Net: A[30] (width=100000nm, material=FullAdder)
* Net: Carry[31] (width=100000nm, material=FullAdder)
* Net: B[30] (width=100000nm, material=FullAdder)
*   Connected pins:
*     - Adder[31].carry_in
* Net: Sum[31] (width=100000nm, material=FullAdder)
* Net: A[31] (width=100000nm, material=FullAdder)
* Net: Carry[32] (width=100000nm, material=FullAdder)
* Net: B[31] (width=100000nm, material=FullAdder)
*   Connected pins:
*     - Adder[32].carry_in
* Net: Sum[32] (width=100000nm, material=FullAdder)
* Net: A[32] (width=100000nm, material=FullAdder)
* Net: Carry[33] (width=100000nm, material=FullAdder)
* Net: B[32] (width=100000nm, material=FullAdder)
*   Connected pins:
*     - Adder[33].carry_in
* Net: Sum[33] (width=100000nm, material=FullAdder)
* Net: A[33] (width=100000nm, material=FullAdder)
* Net: Carry[34] (width=100000nm, material=FullAdder)
* Net: B[33] (width=100000nm, material=FullAdder)
*   Connected pins:
*     - Adder[34].carry_in
* Net: Sum[34] (width=100000nm, material=FullAdder)
* Net: A[34] (width=100000nm, material=FullAdder)
* Net: Carry[35] (width=100000nm, material=FullAdder)
* Net: B[34] (width=100000nm, material=FullAdder)
*   Connected pins:
*     - Adder[35].carry_in
* Net: Sum[35] (width=100000nm, material=FullAdder)
* Net: A[35] (width=100000nm, material=FullAdder)
* Net: Carry[36] (width=100000nm, material=FullAdder)
* Net: B[35] (width=100000nm, material=FullAdder)
*   Connected pins:
*     - Adder[36].carry_in
* Net: Sum[36] (width=100000nm, material=FullAdder)
* Net: A[36] (width=100000nm, material=FullAdder)
* Net: Carry[37] (width=100000nm, material=FullAdder)
* Net: B[36] (width=100000nm, material=FullAdder)
*   Connected pins:
*     - Adder[37].carry_in
* Net: Sum[37] (width=100000nm, material=FullAdder)
* Net: A[37] (width=100000nm, material=FullAdder)
* Net: Carry[38] (width=100000nm, material=FullAdder)
* Net: B[37] (width=100000nm, material=FullAdder)
*   Connected pins:
*     - Adder[38].carry_in
* Net: Sum[38] (width=100000nm, material=FullAdder)
* Net: A[38] (width=100000nm, material=FullAdder)
* Net: Carry[39] (width=100000nm, material=FullAdder)
* Net: B[38] (width=100000nm, material=FullAdder)
*   Connected pins:
*     - Adder[39].carry_in
* Net: Sum[39] (width=100000nm, material=FullAdder)
* Net: A[39] (width=100000nm, material=FullAdder)
* Net: Carry[40] (width=100000nm, material=FullAdder)
* Net: B[39] (width=100000nm, material=FullAdder)
*   Connected pins:
*     - Adder[40].carry_in
* Net: Sum[40] (width=100000nm, material=FullAdder)
* Net: A[40] (width=100000nm, material=FullAdder)
* Net: Carry[41] (width=100000nm, material=FullAdder)
* Net: B[40] (width=100000nm, material=FullAdder)
*   Connected pins:
*     - Adder[41].carry_in
* Net: Sum[41] (width=100000nm, material=FullAdder)
* Net: A[41] (width=100000nm, material=FullAdder)
* Net: Carry[42] (width=100000nm, material=FullAdder)
* Net: B[41] (width=100000nm, material=FullAdder)
*   Connected pins:
*     - Adder[42].carry_in
* Net: Sum[42] (width=100000nm, material=FullAdder)
* Net: A[42] (width=100000nm, material=FullAdder)
* Net: Carry[43] (width=100000nm, material=FullAdder)
* Net: B[42] (width=100000nm, material=FullAdder)
*   Connected pins:
*     - Adder[43].carry_in
* Net: Sum[43] (width=100000nm, material=FullAdder)
* Net: A[43] (width=100000nm, material=FullAdder)
* Net: Carry[44] (width=100000nm, material=FullAdder)
* Net: B[43] (width=100000nm, material=FullAdder)
*   Connected pins:
*     - Adder[44].carry_in
* Net: Sum[44] (width=100000nm, material=FullAdder)
* Net: A[44] (width=100000nm, material=FullAdder)
* Net: Carry[45] (width=100000nm, material=FullAdder)
* Net: B[44] (width=100000nm, material=FullAdder)
*   Connected pins:
*     - Adder[45].carry_in
* Net: Sum[45] (width=100000nm, material=FullAdder)
* Net: A[45] (width=100000nm, material=FullAdder)
* Net: Carry[46] (width=100000nm, material=FullAdder)
* Net: B[45] (width=100000nm, material=FullAdder)
*   Connected pins:
*     - Adder[46].carry_in
* Net: Sum[46] (width=100000nm, material=FullAdder)
* Net: A[46] (width=100000nm, material=FullAdder)
* Net: Carry[47] (width=100000nm, material=FullAdder)
* Net: B[46] (width=100000nm, material=FullAdder)
*   Connected pins:
*     - Adder[47].carry_in
* Net: Sum[47] (width=100000nm, material=FullAdder)
* Net: A[47] (width=100000nm, material=FullAdder)
* Net: Carry[48] (width=100000nm, material=FullAdder)
* Net: B[47] (width=100000nm, material=FullAdder)
*   Connected pins:
*     - Adder[48].carry_in
* Net: Sum[48] (width=100000nm, material=FullAdder)
* Net: A[48] (width=100000nm, material=FullAdder)
* Net: Carry[49] (width=100000nm, material=FullAdder)
* Net: B[48] (width=100000nm, material=FullAdder)
*   Connected pins:
*     - Adder[49].carry_in
* Net: Sum[49] (width=100000nm, material=FullAdder)
* Net: A[49] (width=100000nm, material=FullAdder)
* Net: Carry[50] (width=100000nm, material=FullAdder)
* Net: B[49] (width=100000nm, material=FullAdder)
*   Connected pins:
*     - Adder[50].carry_in
* Net: Sum[50] (width=100000nm, material=FullAdder)
* Net: A[50] (width=100000nm, material=FullAdder)
* Net: Carry[51] (width=100000nm, material=FullAdder)
* Net: B[50] (width=100000nm, material=FullAdder)
*   Connected pins:
*     - Adder[51].carry_in
* Net: Sum[51] (width=100000nm, material=FullAdder)
* Net: A[51] (width=100000nm, material=FullAdder)
* Net: Carry[52] (width=100000nm, material=FullAdder)
* Net: B[51] (width=100000nm, material=FullAdder)
*   Connected pins:
*     - Adder[52].carry_in
* Net: Sum[52] (width=100000nm, material=FullAdder)
* Net: A[52] (width=100000nm, material=FullAdder)
* Net: Carry[53] (width=100000nm, material=FullAdder)
* Net: B[52] (width=100000nm, material=FullAdder)
*   Connected pins:
*     - Adder[53].carry_in
* Net: Sum[53] (width=100000nm, material=FullAdder)
* Net: A[53] (width=100000nm, material=FullAdder)
* Net: Carry[54] (width=100000nm, material=FullAdder)
* Net: B[53] (width=100000nm, material=FullAdder)
*   Connected pins:
*     - Adder[54].carry_in
* Net: Sum[54] (width=100000nm, material=FullAdder)
* Net: A[54] (width=100000nm, material=FullAdder)
* Net: Carry[55] (width=100000nm, material=FullAdder)
* Net: B[54] (width=100000nm, material=FullAdder)
*   Connected pins:
*     - Adder[55].carry_in
* Net: Sum[55] (width=100000nm, material=FullAdder)
* Net: A[55] (width=100000nm, material=FullAdder)
* Net: Carry[56] (width=100000nm, material=FullAdder)
* Net: B[55] (width=100000nm, material=FullAdder)
*   Connected pins:
*     - Adder[56].carry_in
* Net: Sum[56] (width=100000nm, material=FullAdder)
* Net: A[56] (width=100000nm, material=FullAdder)
* Net: Carry[57] (width=100000nm, material=FullAdder)
* Net: B[56] (width=100000nm, material=FullAdder)
*   Connected pins:
*     - Adder[57].carry_in
* Net: Sum[57] (width=100000nm, material=FullAdder)
* Net: A[57] (width=100000nm, material=FullAdder)
* Net: Carry[58] (width=100000nm, material=FullAdder)
* Net: B[57] (width=100000nm, material=FullAdder)
*   Connected pins:
*     - Adder[58].carry_in
* Net: Sum[58] (width=100000nm, material=FullAdder)
* Net: A[58] (width=100000nm, material=FullAdder)
* Net: Carry[59] (width=100000nm, material=FullAdder)
* Net: B[58] (width=100000nm, material=FullAdder)
*   Connected pins:
*     - Adder[59].carry_in
* Net: Sum[59] (width=100000nm, material=FullAdder)
* Net: A[59] (width=100000nm, material=FullAdder)
* Net: Carry[60] (width=100000nm, material=FullAdder)
* Net: B[59] (width=100000nm, material=FullAdder)
*   Connected pins:
*     - Adder[60].carry_in
* Net: Sum[60] (width=100000nm, material=FullAdder)
* Net: A[60] (width=100000nm, material=FullAdder)
* Net: Carry[61] (width=100000nm, material=FullAdder)
* Net: B[60] (width=100000nm, material=FullAdder)
*   Connected pins:
*     - Adder[61].carry_in
* Net: Sum[61] (width=100000nm, material=FullAdder)
* Net: A[61] (width=100000nm, material=FullAdder)
* Net: Carry[62] (width=100000nm, material=FullAdder)
* Net: B[61] (width=100000nm, material=FullAdder)
*   Connected pins:
*     - Adder[62].carry_in
* Net: Sum[62] (width=100000nm, material=FullAdder)
* Net: A[62] (width=100000nm, material=FullAdder)
* Net: Carry[63] (width=100000nm, material=FullAdder)
* Net: B[62] (width=100000nm, material=FullAdder)
*   Connected pins:
*     - Adder[63].carry_in
* Net: Sum[63] (width=100000nm, material=FullAdder)
* Net: A[63] (width=100000nm, material=FullAdder)
* Net: Carry[64] (width=100000nm, material=FullAdder)

* ========================================
* COMPONENTS
* ========================================
XAdder[0] A[0] B[0] Carry[0] Sum[0] Carry[1] FullAdder
XAdder[1] A[1] B[1] Carry[1] Sum[1] Carry[2] FullAdder
XAdder[2] A[2] B[2] Carry[2] Sum[2] Carry[3] FullAdder
XAdder[3] A[3] B[3] Carry[3] Sum[3] Carry[4] FullAdder
XAdder[4] A[4] B[4] Carry[4] Sum[4] Carry[5] FullAdder
XAdder[5] A[5] B[5] Carry[5] Sum[5] Carry[6] FullAdder
XAdder[6] A[6] B[6] Carry[6] Sum[6] Carry[7] FullAdder
XAdder[7] A[7] B[7] Carry[7] Sum[7] Carry[8] FullAdder
XAdder[8] A[8] B[8] Carry[8] Sum[8] Carry[9] FullAdder
XAdder[9] A[9] B[9] Carry[9] Sum[9] Carry[10] FullAdder
XAdder[10] A[10] B[10] Carry[10] Sum[10] Carry[11] FullAdder
XAdder[11] A[11] B[11] Carry[11] Sum[11] Carry[12] FullAdder
XAdder[12] A[12] B[12] Carry[12] Sum[12] Carry[13] FullAdder
XAdder[13] A[13] B[13] Carry[13] Sum[13] Carry[14] FullAdder
XAdder[14] A[14] B[14] Carry[14] Sum[14] Carry[15] FullAdder
XAdder[15] A[15] B[15] Carry[15] Sum[15] Carry[16] FullAdder
XAdder[16] A[16] B[16] Carry[16] Sum[16] Carry[17] FullAdder
XAdder[17] A[17] B[17] Carry[17] Sum[17] Carry[18] FullAdder
XAdder[18] A[18] B[18] Carry[18] Sum[18] Carry[19] FullAdder
XAdder[19] A[19] B[19] Carry[19] Sum[19] Carry[20] FullAdder
XAdder[20] A[20] B[20] Carry[20] Sum[20] Carry[21] FullAdder
XAdder[21] A[21] B[21] Carry[21] Sum[21] Carry[22] FullAdder
XAdder[22] A[22] B[22] Carry[22] Sum[22] Carry[23] FullAdder
XAdder[23] A[23] B[23] Carry[23] Sum[23] Carry[24] FullAdder
XAdder[24] A[24] B[24] Carry[24] Sum[24] Carry[25] FullAdder
XAdder[25] A[25] B[25] Carry[25] Sum[25] Carry[26] FullAdder
XAdder[26] A[26] B[26] Carry[26] Sum[26] Carry[27] FullAdder
XAdder[27] A[27] B[27] Carry[27] Sum[27] Carry[28] FullAdder
XAdder[28] A[28] B[28] Carry[28] Sum[28] Carry[29] FullAdder
XAdder[29] A[29] B[29] Carry[29] Sum[29] Carry[30] FullAdder
XAdder[30] A[30] B[30] Carry[30] Sum[30] Carry[31] FullAdder
XAdder[31] A[31] B[31] Carry[31] Sum[31] Carry[32] FullAdder
XAdder[32] A[32] B[32] Carry[32] Sum[32] Carry[33] FullAdder
XAdder[33] A[33] B[33] Carry[33] Sum[33] Carry[34] FullAdder
XAdder[34] A[34] B[34] Carry[34] Sum[34] Carry[35] FullAdder
XAdder[35] A[35] B[35] Carry[35] Sum[35] Carry[36] FullAdder
XAdder[36] A[36] B[36] Carry[36] Sum[36] Carry[37] FullAdder
XAdder[37] A[37] B[37] Carry[37] Sum[37] Carry[38] FullAdder
XAdder[38] A[38] B[38] Carry[38] Sum[38] Carry[39] FullAdder
XAdder[39] A[39] B[39] Carry[39] Sum[39] Carry[40] FullAdder
XAdder[40] A[40] B[40] Carry[40] Sum[40] Carry[41] FullAdder
XAdder[41] A[41] B[41] Carry[41] Sum[41] Carry[42] FullAdder
XAdder[42] A[42] B[42] Carry[42] Sum[42] Carry[43] FullAdder
XAdder[43] A[43] B[43] Carry[43] Sum[43] Carry[44] FullAdder
XAdder[44] A[44] B[44] Carry[44] Sum[44] Carry[45] FullAdder
XAdder[45] A[45] B[45] Carry[45] Sum[45] Carry[46] FullAdder
XAdder[46] A[46] B[46] Carry[46] Sum[46] Carry[47] FullAdder
XAdder[47] A[47] B[47] Carry[47] Sum[47] Carry[48] FullAdder
XAdder[48] A[48] B[48] Carry[48] Sum[48] Carry[49] FullAdder
XAdder[49] A[49] B[49] Carry[49] Sum[49] Carry[50] FullAdder
XAdder[50] A[50] B[50] Carry[50] Sum[50] Carry[51] FullAdder
XAdder[51] A[51] B[51] Carry[51] Sum[51] Carry[52] FullAdder
XAdder[52] A[52] B[52] Carry[52] Sum[52] Carry[53] FullAdder
XAdder[53] A[53] B[53] Carry[53] Sum[53] Carry[54] FullAdder
XAdder[54] A[54] B[54] Carry[54] Sum[54] Carry[55] FullAdder
XAdder[55] A[55] B[55] Carry[55] Sum[55] Carry[56] FullAdder
XAdder[56] A[56] B[56] Carry[56] Sum[56] Carry[57] FullAdder
XAdder[57] A[57] B[57] Carry[57] Sum[57] Carry[58] FullAdder
XAdder[58] A[58] B[58] Carry[58] Sum[58] Carry[59] FullAdder
XAdder[59] A[59] B[59] Carry[59] Sum[59] Carry[60] FullAdder
XAdder[60] A[60] B[60] Carry[60] Sum[60] Carry[61] FullAdder
XAdder[61] A[61] B[61] Carry[61] Sum[61] Carry[62] FullAdder
XAdder[62] A[62] B[62] Carry[62] Sum[62] Carry[63] FullAdder
XAdder[63] A[63] B[63] Carry[63] Sum[63] Carry[64] FullAdder

* ========================================
* DEVICE EXTRACTION REQUIRES EXPLICIT BINDINGS
* Use 'device: DeviceName.terminal' property
* ========================================

.end
