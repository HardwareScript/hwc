* Hardware Script Native Netlist: Pyramid_3Cube_Space
* Generated by hwc v0.1.6 (Syntax Unification)
* Format: SPICE3

* ========================================
* NETS
* ========================================
* Net: TestNet (pour: Base_Left, material: Aluminum, z: 0.0015mm)
* Net: TestNet (pour: Base_Right, material: Aluminum, z: 0.0015mm)
* Net: TestNet (pour: Top_Center, material: Aluminum, z: 0.0030mm)
* Net: TestNet (width=200000nm, material=Tungsten)
*   Connected pins:
*     - Base_Left.__virtual_Base_Left
*     - Base_Right.__virtual_Base_Right
*     - Top_Center.__virtual_Top_Center

* ========================================
* COMPONENTS (Schematic-Level Subcircuits)
* ========================================
XBase_Left TestNet Plane(Aluminum)
XBase_Right TestNet Plane(Aluminum)
XTop_Center TestNet Plane(Aluminum)

* ========================================
* DEVICE EXTRACTION REQUIRES EXPLICIT BINDINGS
* Use 'device: DeviceName.terminal' property
* ========================================

.end
