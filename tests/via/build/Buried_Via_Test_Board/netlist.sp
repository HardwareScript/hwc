* Hardware Script Native Netlist: Buried_Via_Test_Board
* Generated by hwc v0.1.6 (Syntax Unification)
* Format: SPICE3

* ========================================
* NETS
* ========================================

* ========================================
* COMPONENTS
* ========================================
XBuried_Via SIG Contact(ViaCopper)

.end
