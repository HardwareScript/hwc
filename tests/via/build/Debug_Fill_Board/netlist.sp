* Hardware Script Native Netlist: Debug_Fill_Board
* Generated by hwc v0.1.6 (Syntax Unification)
* Format: SPICE3

* ========================================
* DEVICE EXTRACTION REQUIRES EXPLICIT BINDINGS
* Use 'device: DeviceName.terminal' property
* ========================================

.end
