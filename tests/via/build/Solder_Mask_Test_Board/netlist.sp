* Hardware Script Native Netlist: Solder_Mask_Test_Board
* Generated by hwc v0.1.6 (Syntax Unification)
* Format: SPICE3

* ========================================
* NETS
* ========================================
* Net: GND (pour: GndPlane, material: ViaCopper, z: 1.0950mm)

* ========================================
* COMPONENTS
* ========================================
XGndPlane GND Pour(ViaCopper)
XExposed_Via GND Contact(ViaCopper)
XTented_Via GND Contact(ViaCopper)

.end
