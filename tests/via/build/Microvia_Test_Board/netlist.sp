* Hardware Script Native Netlist: Microvia_Test_Board
* Generated by hwc v0.1.6 (Syntax Unification)
* Format: SPICE3

* ========================================
* NETS
* ========================================

* ========================================
* COMPONENTS
* ========================================
XMicrovia SIG Contact(ViaCopper)

.end
