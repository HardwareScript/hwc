* Hardware Script Native Netlist: Staggered_Via_Test_Board
* Generated by hwc v0.1.6 (Syntax Unification)
* Format: SPICE3

* ========================================
* NETS
* ========================================
* Net: SIG (pour: Connection_Trace, material: ViaCopper, z: 1.2950mm)

* ========================================
* COMPONENTS
* ========================================
XMicrovia_1 SIG Contact(ViaCopper)
XConnection_Trace SIG Pour(ViaCopper)
XMicrovia_2 SIG Contact(ViaCopper)

.end
