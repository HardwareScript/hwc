* Hardware Script Native Netlist: ComplexChain
* Generated by hwc v0.1.6 (Syntax Unification)
* Format: SPICE3

* ========================================
* COMPONENTS
* ========================================
* WARNING: M1 has insufficient pins for MOSFET
* WARNING: M2 has insufficient pins for MOSFET
* WARNING: M3 has insufficient pins for MOSFET
* WARNING: M4 has insufficient pins for MOSFET

* ========================================
* DEVICE EXTRACTION REQUIRES EXPLICIT BINDINGS
* Use 'device: DeviceName.terminal' property
* ========================================

.end
