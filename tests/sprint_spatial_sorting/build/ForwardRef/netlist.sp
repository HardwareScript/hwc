* Hardware Script Native Netlist: ForwardRef
* Generated by hwc v0.1.6 (Syntax Unification)
* Format: SPICE3

* ========================================
* COMPONENTS
* ========================================
MM1 nc_2 nc_0 nc_1 0 NMOS
MM2 nc_5 nc_3 nc_4 0 NMOS

* ========================================
* DEVICE EXTRACTION REQUIRES EXPLICIT BINDINGS
* Use 'device: DeviceName.terminal' property
* ========================================

.end
