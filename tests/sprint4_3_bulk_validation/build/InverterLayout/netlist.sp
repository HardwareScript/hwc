* Hardware Script Native Netlist: InverterLayout
* Generated by hwc v0.1.6 (Syntax Unification)
* Format: SPICE3

* ========================================
* NETS
* ========================================
* Net: VIN (pour: M1_Gate, material: Polysilicon, layer: 5)
* Net: GND (pour: M1_Source, material: Silicon_N, layer: 3)
* Net: VOUT (pour: M1_Drain, material: Silicon_N, layer: 3)
* Net: GND (pour: M1_Bulk, material: Silicon_P, layer: 3)
* Net: VIN (pour: M2_Gate, material: Polysilicon, layer: 5)
* Net: VDD (pour: M2_Source, material: Silicon_P, layer: 3)
* Net: VOUT (pour: M2_Drain, material: Silicon_P, layer: 3)
* Net: VDD (pour: M2_Bulk, material: Silicon_N, layer: 3)
* Net: VIN (width=100000nm, material=Polysilicon)
* Net: GND (width=100000nm, material=Silicon_N)
*   Connected pins:
*     - M2_Gate.anchor
* Net: VOUT (width=100000nm, material=Silicon_N)
*   Connected pins:
*     - M1_Bulk.anchor

* ========================================
* COMPONENTS
* ========================================
XM1_Gate VIN Pour(Polysilicon)
XM1_Source GND Pour(Silicon_N)
XM1_Drain VOUT Pour(Silicon_N)
XM1_Bulk GND Pour(Silicon_P)
XM2_Gate VIN Pour(Polysilicon)
XM2_Source VDD Pour(Silicon_P)
XM2_Drain VOUT Pour(Silicon_P)
XM2_Bulk VDD Pour(Silicon_N)

* ========================================
* EXTRACTED DEVICES (Transistors)
* ========================================
MM1 VOUT VIN GND GND NMOS W=0.40u L=0.40u AS=4.00e-8 AD=4.00e-8 PS=8.00e-4 PD=8.00e-4
MM2 VOUT VIN VDD VDD PMOS W=0.40u L=0.40u AS=4.00e-8 AD=4.00e-8 PS=8.00e-4 PD=8.00e-4

.end
