* Hardware Script Transient Waveform Test
* Space: Serpentine_Resistor_Space_V2
* Generated by hwc v0.2.1
* Format: SPICE3

.include "circuit.sp"

* ========================================
* STIMULUS & ANALYSIS
* ========================================
V_In nIn_entry 0 DC 1.800
V_GND GND 0 DC 0.000
.tran 1.000e-11 2.000e-7
.end
