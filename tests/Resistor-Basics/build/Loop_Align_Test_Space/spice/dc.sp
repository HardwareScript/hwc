* Hardware Script DC Operating Point Test
* Space: Loop_Align_Test_Space
* Generated by hwc v0.2.1
* Format: SPICE3

.include "circuit.sp"

* ========================================
* STIMULUS & ANALYSIS
* ========================================
.op
.end
