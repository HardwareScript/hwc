* Hardware Script Pure Circuit (DUT)
* Space: Via_Test
* Generated by hwc v0.1.6
* Format: SPICE3

* ========================================
* NETS
* ========================================
* Net: A (pour: Poly_Left, material: Polysilicon, z: 0.0000mm)
* Net: A (pour: Contact_Left, material: Aluminum, z: 0.0005mm)
* Net: B (pour: Poly_Right, material: Polysilicon, z: 0.0000mm)
* Net: B (pour: Contact_Right, material: Aluminum, z: 0.0005mm)
* Net: A (width=300nm, material=Tungsten)
*   Connected pins:
*     - Poly_Left.anchor
*     - Poly_Left.__virtual_Poly_Left
*     - Contact_Left.anchor
*     - Contact_Left.__virtual_Contact_Left
*     - Via_Left.__virtual_Via_Left
* Net: B (width=300nm, material=Tungsten)
*   Connected pins:
*     - Poly_Right.anchor
*     - Poly_Right.__virtual_Poly_Right
*     - Contact_Right.anchor
*     - Contact_Right.__virtual_Contact_Right
*     - Via_Right.__virtual_Via_Right

.end
