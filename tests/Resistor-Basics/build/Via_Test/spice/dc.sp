* Hardware Script DC Operating Point Test
* Space: Via_Test
* Generated by hwc v0.2.1
* Format: SPICE3

.include "circuit.sp"

* ========================================
* STIMULUS & ANALYSIS
* ========================================
V_A A 0 DC 1.800
.op
.end
