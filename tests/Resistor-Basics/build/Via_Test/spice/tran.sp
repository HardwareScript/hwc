* Hardware Script Transient Waveform Test
* Space: Via_Test
* Generated by hwc v0.1.6
* Format: SPICE3

.include "circuit.sp"

* ========================================
* STIMULUS & ANALYSIS
* ========================================
V_A A 0 DC 1.800
.tran 200ns
.end
