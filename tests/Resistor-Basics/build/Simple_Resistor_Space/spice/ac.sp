* Hardware Script AC Frequency Response Test
* Space: Simple_Resistor_Space
* Generated by hwc v0.2.1
* Format: SPICE3

.include "circuit.sp"

* ========================================
* STIMULUS & ANALYSIS
* ========================================
V_In In 0 DC 1.800 AC 1.0
V_GND GND 0 DC 0.000
.ac dec 20 1.000e2 1.000e8
.end
