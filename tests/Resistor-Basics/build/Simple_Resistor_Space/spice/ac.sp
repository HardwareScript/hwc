* Hardware Script AC Frequency Response Test
* Space: Simple_Resistor_Space
* Generated by hwc v0.3.1
* Format: SPICE3

.include "circuit.sp"

* ========================================
* STIMULUS & ANALYSIS
* ========================================
V_In In 0 DC 1.800 AC 1.0
V_GND GND 0 DC 0.000
* AC Small-Signal Frequency Response (Configured via Testbench)
.ac dec 20 1.000e2 1.000e8
* Frequency range configured from testbench 'ac:' block
.end
