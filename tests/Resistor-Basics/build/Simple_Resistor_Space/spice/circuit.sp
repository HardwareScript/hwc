* Hardware Script Pure Circuit (DUT)
* Space: Simple_Resistor_Space
* Generated by hwc v0.3.1
* Format: SPICE3

* ========================================
* FOUNDRY PDK MODEL INCLUDES
* ========================================
.include "sky130_fd_pr/models/sky130_fd_pr__res_high_po.model.spice"

* ========================================
* NETS
* ========================================
* Net: In (pour: sky130_res_high_po_polyres, material: Polysilicon, z: 200nm)
* Net: In (pour: sky130_res_high_po_psdm, material: P_Plus_Implant_Mask, z: 0nm)
* Net: In (pour: sky130_res_high_po_npc, material: Npc_Mask, z: 380nm)
* Net: Out (pour: sky130_res_high_po_npc, material: Npc_Mask, z: 380nm)
* Net: In (pour: sky130_res_high_po_li1, material: Titanium_Nitride, z: 580nm)
* Net: In (pour: sky130_res_high_po_metal1, material: Aluminum, z: 830nm)
* Net: Out (pour: sky130_res_high_po_li1, material: Titanium_Nitride, z: 580nm)
* Net: Out (pour: sky130_res_high_po_metal1, material: Aluminum, z: 830nm)
* Net: GND (pour: sky130_res_high_po_tap, material: Tap_Mask, z: 0nm)
* Net: GND (pour: sky130_res_high_po_psdm, material: P_Plus_Implant_Mask, z: 0nm)
* Net: GND (pour: sky130_res_high_po_pdiff, material: P_Plus_Diffusion, z: 0nm)
* Net: GND (pour: sky130_res_high_po_li1, material: Titanium_Nitride, z: 580nm)
* Net: GND (pour: sky130_res_high_po_metal1, material: Aluminum, z: 830nm)
* Net: In (pour: pad_1_metal1, material: Aluminum, z: 830nm)
* Net: In (pour: pad_1_pad, material: Pad_Mask, z: 1.19µm)
* Net: Out (pour: pad_2_metal1, material: Aluminum, z: 830nm)
* Net: Out (pour: pad_2_pad, material: Pad_Mask, z: 1.19µm)
* Net: GND (pour: pad_3_metal1, material: Aluminum, z: 830nm)
* Net: GND (pour: pad_3_pad, material: Pad_Mask, z: 1.19µm)
* Net: In (width=300nm, material=P_Plus_Diffusion)
* Net: Out (width=300nm, material=P_Plus_Diffusion)
* Net: GND (width=300nm, material=P_Plus_Diffusion)

* ========================================
* EXTRACTED DEVICES
* ========================================
Xsky130_res_high_po nIn_li1_0 nOut_li1 nGND_pdiff sky130_fd_pr__res_high_po w=1.41u l=4.00u

* ========================================
* INTEGRATED TRACE PARASITICS
* ========================================
* Via/Contact resistance
Rvia_In_li1_metal1_0 nIn_metal1_0 nIn_li1_0 1.730104e1
* Via/Contact resistance
Rvia_Out_li1_metal1 nOut_metal1 nOut_li1 1.730104e1
* Via/Contact resistance
Rvia_GND_li1_metal1 nGND_metal1 nGND_li1 3.460208e1
* Via/Contact resistance
Rvia_GND_pdiff_li1 nGND_li1 nGND_pdiff 3.460208e1
* Trace resistance
Rtr_In_0_0 nIn_pad nIn_metal1_0 1.260000e1
* Ground capacitance
Cgnd_In_0_0 nIn_metal1_0 GND 2.088455e-15
* Trace resistance
Rtr_Out_1_0 nOut_metal1 nOut_pad 1.260000e1
* Ground capacitance
Cgnd_Out_1_0 nOut_pad GND 2.088455e-15
* Trace resistance
Rtr_GND_2_0 nGND_metal1 nGND_pad 1.979167e1
* Ground capacitance
Cgnd_pour_pad_1_metal1 nIn_pad GND 6.656642e-14
* Ground capacitance
Cgnd_pour_pad_2_metal1 nOut_pad GND 6.656642e-14
* Trace resistance
Rpad_stimulus_bridge_In In nIn_pad 1.000000e-4
* Trace resistance
Rpad_stimulus_bridge_Out Out nOut_pad 1.000000e-4
* Trace resistance
Rpad_stimulus_bridge_GND GND nGND_pad 1.000000e-4

* Total parasitic elements: 14

.end
