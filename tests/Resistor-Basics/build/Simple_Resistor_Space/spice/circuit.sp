* Hardware Script Pure Circuit (DUT)
* Space: Simple_Resistor_Space
* Generated by hwc v0.2.1
* Format: SPICE3

* ========================================
* PDK SUBCIRCUIT: sky130_fd_pr__res_high_po
* ========================================
* Subcircuit 'sky130_fd_pr__res_high_po' uses foundry model
.include "sky130_fd_pr/models/sky130_fd_pr__res_high_po.model.spice"

* ========================================
* NETS
* ========================================
* Net: In (pour: Contact_A_LI, material: Titanium_Silicide, z: 580nm)
* Net: Out (pour: Contact_B_LI, material: Titanium_Silicide, z: 580nm)
* Net: In (pour: Contact_A_Metal, material: Aluminum, z: 830nm)
* Net: Out (pour: Contact_B_Metal, material: Aluminum, z: 830nm)
* Net: In (pour: In_Pad, material: Aluminum, z: 830nm)
* Net: Out (pour: Out_Pad, material: Aluminum, z: 830nm)
* Net: GND (pour: Bulk_Tap_Diff, material: P_Plus_Diffusion, z: 0nm)
* Net: GND (pour: Bulk_Tap_LI, material: Titanium_Silicide, z: 580nm)
* Net: In (width=300nm, material=Tungsten)
*   Connected pins:
*     - Contact_A_LI.anchor
*     - Contact_A_LI.__virtual_Contact_A_LI
*     - Via_A_Poly.__virtual_Via_A_Poly
*     - Contact_A_Metal.anchor
*     - Contact_A_Metal.__virtual_Contact_A_Metal
*     - Via_A_Metal.__virtual_Via_A_Metal
*     - In_Pad.anchor
*     - In_Pad.__virtual_In_Pad
* Net: Out (width=300nm, material=Tungsten)
*   Connected pins:
*     - Contact_B_LI.anchor
*     - Contact_B_LI.__virtual_Contact_B_LI
*     - Via_B_Poly.__virtual_Via_B_Poly
*     - Contact_B_Metal.anchor
*     - Contact_B_Metal.__virtual_Contact_B_Metal
*     - Via_B_Metal.__virtual_Via_B_Metal
*     - Out_Pad.anchor
*     - Out_Pad.__virtual_Out_Pad
* Net: GND (width=300nm, material=Tungsten)
*   Connected pins:
*     - Bulk_Tap_Diff.anchor
*     - Bulk_Tap_Diff.__virtual_Bulk_Tap_Diff
*     - Bulk_Tap_Contact.__virtual_Bulk_Tap_Contact
*     - Bulk_Tap_LI.anchor
*     - Bulk_Tap_LI.__virtual_Bulk_Tap_LI

* ========================================
* EXTRACTED DEVICES
* ========================================
XR1 In Out GND sky130_fd_pr__res_high_po W=1.41u L=4.00u

* ========================================
* INTEGRATED TRACE PARASITICS
* ========================================
* Trace resistance
RRtr_In_0 nIn_entry In 8.355556e-1
* Ground capacitance
CCgnd_In_0 In GND 2.210005e-16
* Trace resistance
RRtr_Out_0 nOut_entry Out 8.355556e-1
* Ground capacitance
CCgnd_Out_0 Out GND 2.210005e-16

* Total parasitic elements: 4

.end
