* Hardware Script Pure Circuit (DUT)
* Space: Simple_Resistor_Space
* Generated by hwc v0.3.1
* Format: SPICE3

* ========================================
* FOUNDRY PDK MODEL INCLUDES
* ========================================
.include "sky130_fd_pr/models/sky130_fd_pr__res_high_po.model.spice"

* ========================================
* NETS
* ========================================
* Net: In (pour: sky130_res_high_po, material: Polysilicon, z: 200nm)
* Net: In (pour: sky130_res_high_po, material: P_Plus_Implant_Mask, z: 0nm)
* Net: In (pour: sky130_res_high_po, material: Npc_Mask, z: 380nm)
* Net: Out (pour: sky130_res_high_po, material: Npc_Mask, z: 380nm)
* Net: In (pour: sky130_res_high_po, material: Titanium_Nitride, z: 580nm)
* Net: In (pour: sky130_res_high_po, material: Aluminum, z: 830nm)
* Net: Out (pour: sky130_res_high_po, material: Titanium_Nitride, z: 580nm)
* Net: Out (pour: sky130_res_high_po, material: Aluminum, z: 830nm)
* Net: GND (pour: sky130_res_high_po, material: Tap_Mask, z: 0nm)
* Net: GND (pour: sky130_res_high_po, material: P_Plus_Implant_Mask, z: 0nm)
* Net: GND (pour: sky130_res_high_po, material: P_Plus_Diffusion, z: 0nm)
* Net: GND (pour: sky130_res_high_po, material: Titanium_Nitride, z: 580nm)
* Net: GND (pour: sky130_res_high_po, material: Aluminum, z: 830nm)
* Net: In (pour: pad, material: Aluminum, z: 830nm)
* Net: In (pour: pad, material: Pad_Mask, z: 1.19µm)
* Net: Out (pour: pad, material: Aluminum, z: 830nm)
* Net: Out (pour: pad, material: Pad_Mask, z: 1.19µm)
* Net: GND (pour: pad, material: Aluminum, z: 830nm)
* Net: GND (pour: pad, material: Pad_Mask, z: 1.19µm)
* Net: In (width=300nm, material=Aluminum)
*   Connected pins:
*     - sky130_res_high_po.anchor
*     - sky130_res_high_po.__virtual_sky130_res_high_po
*     - sky130_res_high_po.anchor
*     - sky130_res_high_po.__virtual_sky130_res_high_po
*     - sky130_res_high_po.anchor
*     - sky130_res_high_po.__virtual_sky130_res_high_po
*     - sky130_res_high_po.anchor
*     - sky130_res_high_po.__virtual_sky130_res_high_po
*     - sky130_res_high_po.anchor
*     - sky130_res_high_po.__virtual_sky130_res_high_po
*     - pad.anchor
*     - pad.__virtual_pad
*     - pad.anchor
*     - pad.__virtual_pad
*     - .__virtual_
*     - .__virtual_
*     - .__virtual_
*     - .__virtual_
*     - .__virtual_
*     - .__virtual_
*     - .__virtual_
*     - .__virtual_
*     - .__virtual_
* Net: Out (width=300nm, material=Aluminum)
*   Connected pins:
*     - sky130_res_high_po.anchor
*     - sky130_res_high_po.__virtual_sky130_res_high_po
*     - sky130_res_high_po.anchor
*     - sky130_res_high_po.__virtual_sky130_res_high_po
*     - sky130_res_high_po.anchor
*     - sky130_res_high_po.__virtual_sky130_res_high_po
*     - pad.anchor
*     - pad.__virtual_pad
*     - pad.anchor
*     - pad.__virtual_pad
*     - .__virtual_
*     - .__virtual_
*     - .__virtual_
* Net: GND (width=300nm, material=Aluminum)
*   Connected pins:
*     - sky130_res_high_po.anchor
*     - sky130_res_high_po.__virtual_sky130_res_high_po
*     - sky130_res_high_po.anchor
*     - sky130_res_high_po.__virtual_sky130_res_high_po
*     - sky130_res_high_po.anchor
*     - sky130_res_high_po.__virtual_sky130_res_high_po
*     - sky130_res_high_po.anchor
*     - sky130_res_high_po.__virtual_sky130_res_high_po
*     - sky130_res_high_po.anchor
*     - sky130_res_high_po.__virtual_sky130_res_high_po
*     - pad.anchor
*     - pad.__virtual_pad
*     - pad.anchor
*     - pad.__virtual_pad
*     - .__virtual_
*     - .__virtual_

* ========================================
* EXTRACTED DEVICES
* ========================================
Xsky130_res_high_po nIn_li1_0 nOut_li1 nGND_pdiff sky130_fd_pr__res_high_po W=1.41u L=3.04u

* ========================================
* INTEGRATED TRACE PARASITICS
* ========================================
* Via/Contact resistance
Rvia_In_li1_metal1_0 nIn_metal1_0 nIn_li1_0 1.153403e1
* Via/Contact resistance
Rvia_Out_li1_metal1 nOut_metal1 nOut_li1 1.153403e1
* Via/Contact resistance
Rvia_GND_li1_metal1 nGND_metal1 nGND_li1 3.460208e1
* Via/Contact resistance
Rvia_GND_pdiff_li1 nGND_li1 nGND_pdiff 3.460208e1
* Trace resistance
Rtr_In_0_0 In nIn_metal1_0 1.128000e-1
* Ground capacitance
Cgnd_In_0_0 nIn_metal1_0 GND 3.315008e-16
* Trace resistance
Rtr_Out_1_0 nOut_metal1 Out 1.128000e-1
* Ground capacitance
Cgnd_Out_1_0 Out GND 3.315008e-16
* Trace resistance
Rtr_GND_2_0 nGND_metal1 GND 7.833333e-2
* Ground capacitance
Cgnd_pour_sky130_res_high_po nIn_metal1_0 GND 1.558054e-16
* Ground capacitance
Cgnd_pour_sky130_res_high_po nOut_metal1 GND 1.558054e-16
* Ground capacitance
Cgnd_pour_pad In GND 2.302089e-16
* Ground capacitance
Cgnd_pour_pad In GND 8.287520e-17
* Ground capacitance
Cgnd_pour_pad Out GND 2.302089e-16
* Ground capacitance
Cgnd_pour_pad Out GND 8.287520e-17

* Total parasitic elements: 15

.end
