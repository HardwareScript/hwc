* Hardware Script Pure Circuit (DUT)
* Space: Simple_Resistor_Space
* Generated by hwc v0.2.1
* Format: SPICE3

* ========================================
* PDK SUBCIRCUIT: sky130_fd_pr__res_high_po
* ========================================
.subckt sky130_fd_pr__res_high_po A B BULK W=1u L=1u
RR_head A node_1 362
RR_tail node_2 B 362
RR_body node_1 node_2 {3.500000e2 * (L / W)}
CC_sub1 A BULK {2.000000e-15 * W * L}
CC_sub2 B BULK {2.000000e-15 * W * L}
.ends sky130_fd_pr__res_high_po

* ========================================
* NETS
* ========================================
* Net: In (pour: Contact_A_LI, material: Titanium_Silicide, z: 580nm)
* Net: Out (pour: Contact_B_LI, material: Titanium_Silicide, z: 580nm)
* Net: In (pour: Contact_A_Metal, material: Aluminum, z: 830nm)
* Net: Out (pour: Contact_B_Metal, material: Aluminum, z: 830nm)
* Net: In (pour: In_Pad, material: Aluminum, z: 830nm)
* Net: Out (pour: Out_Pad, material: Aluminum, z: 830nm)
* Net: GND (pour: Bulk_Tap_Diff, material: P_Plus_Diffusion, z: 0nm)
* Net: GND (pour: Bulk_Tap_LI, material: Titanium_Silicide, z: 580nm)
* Net: In (width=300nm, material=Tungsten)
*   Connected pins:
*     - Contact_A_LI.anchor
*     - Contact_A_LI.__virtual_Contact_A_LI
*     - Via_A_Poly_0.__virtual_Via_A_Poly_0
*     - Via_A_Poly_1.__virtual_Via_A_Poly_1
*     - Via_A_Poly_2.__virtual_Via_A_Poly_2
*     - Contact_A_Metal.anchor
*     - Contact_A_Metal.__virtual_Contact_A_Metal
*     - Via_A_Metal_0.__virtual_Via_A_Metal_0
*     - Via_A_Metal_1.__virtual_Via_A_Metal_1
*     - Via_A_Metal_2.__virtual_Via_A_Metal_2
*     - In_Pad.anchor
*     - In_Pad.__virtual_In_Pad
* Net: Out (width=300nm, material=Tungsten)
*   Connected pins:
*     - Contact_B_LI.anchor
*     - Contact_B_LI.__virtual_Contact_B_LI
*     - Via_B_Poly_0.__virtual_Via_B_Poly_0
*     - Via_B_Poly_1.__virtual_Via_B_Poly_1
*     - Via_B_Poly_2.__virtual_Via_B_Poly_2
*     - Contact_B_Metal.anchor
*     - Contact_B_Metal.__virtual_Contact_B_Metal
*     - Via_B_Metal_0.__virtual_Via_B_Metal_0
*     - Via_B_Metal_1.__virtual_Via_B_Metal_1
*     - Via_B_Metal_2.__virtual_Via_B_Metal_2
*     - Out_Pad.anchor
*     - Out_Pad.__virtual_Out_Pad
* Net: GND (width=300nm, material=Tungsten)
*   Connected pins:
*     - Bulk_Tap_Diff.anchor
*     - Bulk_Tap_Diff.__virtual_Bulk_Tap_Diff
*     - Bulk_Tap_Contact.__virtual_Bulk_Tap_Contact
*     - Bulk_Tap_LI.anchor
*     - Bulk_Tap_LI.__virtual_Bulk_Tap_LI

* ========================================
* EXTRACTED DEVICES
* ========================================
XR1 In Out GND sky130_fd_pr__res_high_po W=1.41u L=3.20u

* ========================================
* INTEGRATED TRACE PARASITICS
* ========================================
* Trace resistance
RRtr_In_0 nIn_entry In 6.527778e-1
* Ground capacitance
CCgnd_In_0 In GND 1.726567e-16
* Trace resistance
RRtr_Out_0 nOut_entry Out 6.527778e-1
* Ground capacitance
CCgnd_Out_0 Out GND 1.726567e-16
* Trace resistance
Rvia_In_polyres_li1 In In_post_via_In_polyres_li1 1.468558e1
* Trace resistance
Rvia_Out_polyres_li1 Out Out_post_via_Out_polyres_li1 1.468558e1
* Trace resistance
Rvia_GND_pdiff_li1 GND GND_post_via_GND_pdiff_li1 4.405673e1
* Trace resistance
Rvia_In_li1_metal1 In In_post_via_In_li1_metal1 1.468558e1
* Trace resistance
Rvia_Out_li1_metal1 Out Out_post_via_Out_li1_metal1 1.468558e1

* Total parasitic elements: 9

.end
