* Hardware Script Pure Circuit (DUT)
* Space: Simple_Resistor_Space
* Generated by hwc v0.2.1
* Format: SPICE3

* ========================================
* NETS
* ========================================
* Net: In (pour: In_li1, material: Titanium_Silicide, z: 580nm)
* Net: In (pour: In_metal1, material: Aluminum, z: 830nm)
* Net: Out (pour: Out_li1, material: Titanium_Silicide, z: 580nm)
* Net: Out (pour: Out_metal1, material: Aluminum, z: 830nm)
* Net: GND (pour: GND_pdiff, material: P_Plus_Diffusion, z: 0nm)
* Net: GND (pour: GND_li1, material: Titanium_Silicide, z: 580nm)
* Net: GND (pour: GND_metal1, material: Aluminum, z: 830nm)
* Net: In (pour: In_metal1_1, material: Aluminum, z: 830nm)
* Net: Out (pour: Out_metal1_1, material: Aluminum, z: 830nm)
* Net: In (width=300nm, material=Aluminum)
* Net: Out (width=300nm, material=Aluminum)
* Net: GND (width=300nm, material=Aluminum)

* ========================================
* EXTRACTED DEVICES
* ========================================
XR1 GND Out In Resistor L=3.20u W=1.41u

* ========================================
* INTEGRATED TRACE PARASITICS
* ========================================
* Via/Contact resistance
Rvia_In_polyres_li1 nIn_li1 nIn_polyres 1.468558e1
* Via/Contact resistance
Rvia_In_li1_metal1 nIn_metal1 nIn_li1 1.468558e1
* Via/Contact resistance
Rvia_Out_polyres_li1 nOut_li1 nOut_polyres 1.468558e1
* Via/Contact resistance
Rvia_Out_li1_metal1 nOut_metal1 nOut_li1 1.468558e1
* Via/Contact resistance
Rvia_GND_li1_metal1 nGND_metal1 nGND_li1 4.405673e1
* Via/Contact resistance
Rvia_GND_pdiff_li1 nGND_li1 nGND_pdiff 4.405673e1
* Trace resistance
Rtr_In_0_0 In nIn_metal1 8.877778e-1
* Ground capacitance
Cgnd_In_0_0 nIn_metal1 BULK 2.348131e-16
* Trace resistance
Rtr_Out_1_0 nOut_metal1 Out 8.877778e-1
* Ground capacitance
Cgnd_Out_1_0 Out BULK 2.348131e-16
* Ground capacitance
Cgnd_pour_In_li1 nIn_li1 BULK 9.737836e-17
* Ground capacitance
Cgnd_pour_In_metal1 nIn_metal1 BULK 1.298378e-16
* Ground capacitance
Cgnd_pour_Out_li1 nOut_li1 BULK 9.737836e-17
* Ground capacitance
Cgnd_pour_Out_metal1 nOut_metal1 BULK 1.298378e-16
* Ground capacitance
Cgnd_pour_GND_li1 nGND_li1 BULK 2.762507e-17
* Ground capacitance
Cgnd_pour_GND_metal1 nGND_metal1 BULK 3.683342e-17
* Ground capacitance
Cgnd_pour_In_metal1_1 In BULK 2.302089e-16
* Ground capacitance
Cgnd_pour_Out_metal1_1 Out BULK 2.302089e-16

* Total parasitic elements: 18

.end
