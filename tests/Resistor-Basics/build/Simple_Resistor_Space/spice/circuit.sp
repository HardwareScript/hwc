* Hardware Script Pure Circuit (DUT)
* Space: Simple_Resistor_Space
* Generated by hwc v0.2.1
* Format: SPICE3

* ========================================
* PDK SUBCIRCUIT: sky130_fd_pr__res_high_po
* ========================================
.subckt sky130_fd_pr__res_high_po A B BULK W=1u L=1u
RR_head A node_1 362
RR_tail node_2 B 362
RR_body node_1 node_2 {3.500000e2 * (L / W)} tc1=-0.00147 tc2=0.0000027 vc1=-0.00032 vc2=0.000018
CC_sub1 A BULK {2.000000e-15 * W * L}
CC_sub2 B BULK {2.000000e-15 * W * L}
.ends sky130_fd_pr__res_high_po

* ========================================
* NETS
* ========================================
* Net: In (pour: Contact_A_LI, material: Titanium_Silicide, z: 580nm)
* Net: Out (pour: Contact_B_LI, material: Titanium_Silicide, z: 580nm)
* Net: In (pour: Contact_A_Metal, material: Aluminum, z: 830nm)
* Net: Out (pour: Contact_B_Metal, material: Aluminum, z: 830nm)
* Net: In (pour: In_Pad, material: Aluminum, z: 830nm)
* Net: Out (pour: Out_Pad, material: Aluminum, z: 830nm)
* Net: GND (pour: Bulk_Tap_Diff, material: P_Plus_Diffusion, z: 0nm)
* Net: GND (pour: Bulk_Tap_LI, material: Titanium_Silicide, z: 580nm)
* Net: GND (pour: Bulk_Tap_Metal, material: Aluminum, z: 830nm)
* Net: In (width=300nm, material=Tungsten)
*   Connected pins:
*     - Contact_A_LI.anchor
*     - Contact_A_LI.__virtual_Contact_A_LI
*     - Via_A_Poly_0.__virtual_Via_A_Poly_0
*     - Via_A_Poly_1.__virtual_Via_A_Poly_1
*     - Via_A_Poly_2.__virtual_Via_A_Poly_2
*     - Contact_A_Metal.anchor
*     - Contact_A_Metal.__virtual_Contact_A_Metal
*     - Via_A_Metal_0.__virtual_Via_A_Metal_0
*     - Via_A_Metal_1.__virtual_Via_A_Metal_1
*     - Via_A_Metal_2.__virtual_Via_A_Metal_2
*     - In_Pad.anchor
*     - In_Pad.__virtual_In_Pad
* Net: Out (width=300nm, material=Tungsten)
*   Connected pins:
*     - Contact_B_LI.anchor
*     - Contact_B_LI.__virtual_Contact_B_LI
*     - Via_B_Poly_0.__virtual_Via_B_Poly_0
*     - Via_B_Poly_1.__virtual_Via_B_Poly_1
*     - Via_B_Poly_2.__virtual_Via_B_Poly_2
*     - Contact_B_Metal.anchor
*     - Contact_B_Metal.__virtual_Contact_B_Metal
*     - Via_B_Metal_0.__virtual_Via_B_Metal_0
*     - Via_B_Metal_1.__virtual_Via_B_Metal_1
*     - Via_B_Metal_2.__virtual_Via_B_Metal_2
*     - Out_Pad.anchor
*     - Out_Pad.__virtual_Out_Pad
* Net: GND (width=300nm, material=Tungsten)
*   Connected pins:
*     - Bulk_Tap_Diff.anchor
*     - Bulk_Tap_Diff.__virtual_Bulk_Tap_Diff
*     - Bulk_Tap_Contact.__virtual_Bulk_Tap_Contact
*     - Bulk_Tap_LI.anchor
*     - Bulk_Tap_LI.__virtual_Bulk_Tap_LI
*     - Bulk_Tap_Metal.anchor
*     - Bulk_Tap_Metal.__virtual_Bulk_Tap_Metal
*     - Bulk_Tap_Via.__virtual_Bulk_Tap_Via

* ========================================
* EXTRACTED DEVICES
* ========================================
XR1 nIn_li1 nOut_li1 nGND_pdiff sky130_fd_pr__res_high_po W=1.41u L=3.20u

* ========================================
* INTEGRATED TRACE PARASITICS
* ========================================
* Via/Contact resistance
Rvia_In_li1_metal1 nIn_metal1 nIn_li1 1.468558e1
* Via/Contact resistance
Rvia_Out_li1_metal1 nOut_metal1 nOut_li1 1.468558e1
* Via/Contact resistance
Rvia_GND_li1_metal1 nGND_metal1 nGND_li1 4.405673e1
* Via/Contact resistance
Rvia_GND_pdiff_li1 nGND_li1 nGND_pdiff 4.405673e1
* Trace resistance
Rtr_Out_0_0 nOut_metal1 Out 6.527778e-1
* Ground capacitance
Cgnd_Out_0_0 Out GND 1.726567e-16
* Trace resistance
Rtr_In_1_0 In nIn_metal1 6.527778e-1
* Ground capacitance
Cgnd_In_1_0 nIn_metal1 GND 1.726567e-16
* Ground capacitance
Cgnd_pour_Contact_A_Metal nIn_metal1 GND 1.298378e-16
* Ground capacitance
Cgnd_pour_Contact_B_Metal nOut_metal1 GND 1.298378e-16
* Ground capacitance
Cgnd_pour_In_Pad In GND 2.302089e-16
* Ground capacitance
Cgnd_pour_Out_Pad Out GND 2.302089e-16

* Total parasitic elements: 12

.end
