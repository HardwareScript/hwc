* Hardware Script Native Netlist: Simple_Resistor_Space
* Generated by hwc v0.1.6 (Syntax Unification)
* Format: SPICE3

* ========================================
* NETS
* ========================================
* Net: In (pour: Contact_A, material: Aluminum, z: 0.0000mm)
* Net: Out (pour: Contact_B, material: Aluminum, z: 0.0000mm)
* Net: In (pour: In_Pad, material: Aluminum, z: 0.0000mm)
* Net: Out (pour: Out_Pad, material: Aluminum, z: 0.0000mm)
* Net: In (width=200nm, material=Tungsten)
*   Connected pins:
*     - Contact_A.anchor
*     - Contact_A.__virtual_Contact_A
*     - Via_A.__virtual_Via_A
*     - In_Pad.anchor
*     - In_Pad.__virtual_In_Pad
* Net: Out (width=200nm, material=Tungsten)
*   Connected pins:
*     - Contact_B.anchor
*     - Contact_B.__virtual_Contact_B
*     - Via_B.__virtual_Via_B
*     - Out_Pad.anchor
*     - Out_Pad.__virtual_Out_Pad

* ========================================
* EXTRACTED DEVICES
* ========================================
RR1 In Out 400.00

* ========================================
* AUTOMATIC STIMULUS & MODELS
* ========================================
V_In In 0 DC 1.800
V_Out Out 0 DC 0.000
Vgnd GND 0 0
.op
.end
