* Hardware Script Transient Waveform Test
* Space: Serpentine_Resistor_Space
* Generated by hwc v0.1.6
* Format: SPICE3

* ========================================
* NETS
* ========================================
* Net: In (pour: Contact_In, material: Aluminum, z: 0.0000mm)
* Net: Out (pour: Contact_Out, material: Aluminum, z: 0.0000mm)
* Net: In (pour: In_Pad, material: Aluminum, z: 0.0000mm)
* Net: Out (pour: Out_Pad, material: Aluminum, z: 0.0000mm)
* Net: In (width=200nm, material=Tungsten)
*   Connected pins:
*     - Contact_In.anchor
*     - Contact_In.__virtual_Contact_In
*     - Via_In.__virtual_Via_In
*     - In_Pad.anchor
*     - In_Pad.__virtual_In_Pad
*     - In_Pad.__virtual_In_Pad
*     - Contact_In.__virtual_Contact_In
*     - In_Pad.__virtual_In_Pad
*     - Contact_In.__virtual_Contact_In
* Net: Out (width=200nm, material=Tungsten)
*   Connected pins:
*     - Contact_Out.anchor
*     - Contact_Out.__virtual_Contact_Out
*     - Via_Out.__virtual_Via_Out
*     - Out_Pad.anchor
*     - Out_Pad.__virtual_Out_Pad
*     - Contact_Out.__virtual_Contact_Out
*     - Out_Pad.__virtual_Out_Pad
*     - Contact_Out.__virtual_Contact_Out
*     - Out_Pad.__virtual_Out_Pad
* Net: TEMP_NET (width=200nm, material=Tungsten)

* ========================================
* EXTRACTED DEVICES
* ========================================
RR1 nc Out 400.00

* ========================================
* STIMULUS & ANALYSIS
* ========================================
V_In In 0 PULSE(0 1.800 10ns 1ns 1ns 50ns 100ns)
V_Out Out 0 DC 0
Vgnd GND 0 0
.tran 200ns
.plot tran V(In) V(Out) I(RR1)
.end
