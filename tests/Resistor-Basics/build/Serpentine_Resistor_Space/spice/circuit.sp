* Hardware Script Pure Circuit (DUT)
* Space: Serpentine_Resistor_Space
* Generated by hwc v0.2.1
* Format: SPICE3

* ========================================
* PDK SUBCIRCUIT: sky130_fd_pr__res_high_po
* ========================================
* Subcircuit 'sky130_fd_pr__res_high_po' uses foundry model
.include "sky130_fd_pr/models/sky130_fd_pr__res_high_po.model.spice"

* ========================================
* NETS
* ========================================
* Net: In (pour: Contact_A_LI, material: Titanium_Silicide, z: 380nm)
* Net: In (pour: Contact_A_Metal, material: Aluminum, z: 630nm)
* Net: Out (pour: Contact_B_LI, material: Titanium_Silicide, z: 380nm)
* Net: Out (pour: Contact_B_Metal, material: Aluminum, z: 630nm)
* Net: In (pour: In_Pad, material: Aluminum, z: 630nm)
* Net: Out (pour: Out_Pad, material: Aluminum, z: 630nm)
* Net: In (width=300nm, material=Tungsten)
*   Connected pins:
*     - Contact_A_LI.anchor
*     - Contact_A_LI.__virtual_Contact_A_LI
*     - Via_A_Poly.__virtual_Via_A_Poly
*     - Contact_A_Metal.anchor
*     - Contact_A_Metal.__virtual_Contact_A_Metal
*     - Via_A_Metal.__virtual_Via_A_Metal
*     - In_Pad.anchor
*     - In_Pad.__virtual_In_Pad
* Net: Out (width=300nm, material=Tungsten)
*   Connected pins:
*     - Contact_B_LI.anchor
*     - Contact_B_LI.__virtual_Contact_B_LI
*     - Via_B_Poly.__virtual_Via_B_Poly
*     - Contact_B_Metal.anchor
*     - Contact_B_Metal.__virtual_Contact_B_Metal
*     - Via_B_Metal.__virtual_Via_B_Metal
*     - Out_Pad.anchor
*     - Out_Pad.__virtual_Out_Pad
* Net: GND (width=300nm, material=Tungsten)

* ========================================
* EXTRACTED DEVICES
* ========================================
XR1 In Out GND sky130_fd_pr__res_high_po W=1.00u L=10.00u

.end
