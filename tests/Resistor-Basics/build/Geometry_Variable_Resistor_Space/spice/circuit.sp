* Hardware Script Pure Circuit (DUT)
* Space: Geometry_Variable_Resistor_Space
* Generated by hwc v0.2.1
* Format: SPICE3

* ========================================
* PDK SUBCIRCUIT: sky130_fd_pr__res_high_po
* ========================================
.subckt sky130_fd_pr__res_high_po A B BULK W=1u L=1u
RR_head A node_1 362
RR_tail node_2 B 362
RR_body node_1 node_2 {3.500000e2 * (L / W)} tc1=-0.00147 tc2=0.0000027 vc1=-0.00032 vc2=0.000018
CC_sub1 A BULK {2.000000e-15 * W * L}
CC_sub2 B BULK {2.000000e-15 * W * L}
.ends sky130_fd_pr__res_high_po

* ========================================
* NETS
* ========================================
* Net: In1 (pour: Contact_A_LI, material: Titanium_Silicide, z: 580nm)
* Net: In1 (pour: Contact_A_Metal, material: Aluminum, z: 830nm)
* Net: Out1 (pour: Contact_B_LI, material: Titanium_Silicide, z: 580nm)
* Net: Out1 (pour: Contact_B_Metal, material: Aluminum, z: 830nm)
* Net: GND (pour: Bulk_Tap_Diff, material: P_Plus_Diffusion, z: 0nm)
* Net: GND (pour: Bulk_Tap_LI, material: Titanium_Silicide, z: 580nm)
* Net: GND (pour: Bulk_Tap_Metal, material: Aluminum, z: 830nm)
* Net: In2 (pour: Contact_A_LI, material: Titanium_Silicide, z: 580nm)
* Net: In2 (pour: Contact_A_Metal, material: Aluminum, z: 830nm)
* Net: Out2 (pour: Contact_B_LI, material: Titanium_Silicide, z: 580nm)
* Net: Out2 (pour: Contact_B_Metal, material: Aluminum, z: 830nm)
* Net: GND (pour: Bulk_Tap_Diff, material: P_Plus_Diffusion, z: 0nm)
* Net: GND (pour: Bulk_Tap_LI, material: Titanium_Silicide, z: 580nm)
* Net: GND (pour: Bulk_Tap_Metal, material: Aluminum, z: 830nm)
* Net: In3 (pour: Contact_A_LI, material: Titanium_Silicide, z: 580nm)
* Net: In3 (pour: Contact_A_Metal, material: Aluminum, z: 830nm)
* Net: Out3 (pour: Contact_B_LI, material: Titanium_Silicide, z: 580nm)
* Net: Out3 (pour: Contact_B_Metal, material: Aluminum, z: 830nm)
* Net: GND (pour: Bulk_Tap_Diff, material: P_Plus_Diffusion, z: 0nm)
* Net: GND (pour: Bulk_Tap_LI, material: Titanium_Silicide, z: 580nm)
* Net: GND (pour: Bulk_Tap_Metal, material: Aluminum, z: 830nm)
* Net: GND (pour: GND_Bus, material: Aluminum, z: 830nm)
* Net: In1 (width=300nm, material=Aluminum)
*   Connected pins:
*     - Contact_A_LI.anchor
*     - Contact_A_LI.__virtual_Contact_A_LI
*     - Contact_A_Metal.anchor
*     - Contact_A_Metal.__virtual_Contact_A_Metal
*     - Via_In1_polyres_li1.__virtual_Via_In1_polyres_li1
*     - Via_In1_polyres_li1_1.__virtual_Via_In1_polyres_li1_1
*     - Via_In1_polyres_li1_2.__virtual_Via_In1_polyres_li1_2
*     - Via_In1_li1_metal1.__virtual_Via_In1_li1_metal1
*     - Via_In1_li1_metal1_1.__virtual_Via_In1_li1_metal1_1
*     - Via_In1_li1_metal1_2.__virtual_Via_In1_li1_metal1_2
* Net: Out1 (width=300nm, material=Aluminum)
*   Connected pins:
*     - Contact_B_LI.anchor
*     - Contact_B_LI.__virtual_Contact_B_LI
*     - Contact_B_Metal.anchor
*     - Contact_B_Metal.__virtual_Contact_B_Metal
*     - Via_Out1_polyres_li1.__virtual_Via_Out1_polyres_li1
*     - Via_Out1_polyres_li1_1.__virtual_Via_Out1_polyres_li1_1
*     - Via_Out1_polyres_li1_2.__virtual_Via_Out1_polyres_li1_2
*     - Via_Out1_li1_metal1.__virtual_Via_Out1_li1_metal1
*     - Via_Out1_li1_metal1_1.__virtual_Via_Out1_li1_metal1_1
*     - Via_Out1_li1_metal1_2.__virtual_Via_Out1_li1_metal1_2
* Net: In2 (width=300nm, material=Aluminum)
*   Connected pins:
*     - Contact_A_LI.anchor
*     - Contact_A_LI.__virtual_Contact_A_LI
*     - Contact_A_Metal.anchor
*     - Contact_A_Metal.__virtual_Contact_A_Metal
*     - Via_In2_polyres_li1.__virtual_Via_In2_polyres_li1
*     - Via_In2_polyres_li1_1.__virtual_Via_In2_polyres_li1_1
*     - Via_In2_polyres_li1_2.__virtual_Via_In2_polyres_li1_2
*     - Via_In2_li1_metal1.__virtual_Via_In2_li1_metal1
*     - Via_In2_li1_metal1_1.__virtual_Via_In2_li1_metal1_1
*     - Via_In2_li1_metal1_2.__virtual_Via_In2_li1_metal1_2
* Net: Out2 (width=300nm, material=Aluminum)
*   Connected pins:
*     - Contact_B_LI.anchor
*     - Contact_B_LI.__virtual_Contact_B_LI
*     - Contact_B_Metal.anchor
*     - Contact_B_Metal.__virtual_Contact_B_Metal
*     - Via_Out2_polyres_li1.__virtual_Via_Out2_polyres_li1
*     - Via_Out2_polyres_li1_1.__virtual_Via_Out2_polyres_li1_1
*     - Via_Out2_polyres_li1_2.__virtual_Via_Out2_polyres_li1_2
*     - Via_Out2_li1_metal1.__virtual_Via_Out2_li1_metal1
*     - Via_Out2_li1_metal1_1.__virtual_Via_Out2_li1_metal1_1
*     - Via_Out2_li1_metal1_2.__virtual_Via_Out2_li1_metal1_2
* Net: In3 (width=300nm, material=Aluminum)
*   Connected pins:
*     - Contact_A_LI.anchor
*     - Contact_A_LI.__virtual_Contact_A_LI
*     - Contact_A_Metal.anchor
*     - Contact_A_Metal.__virtual_Contact_A_Metal
*     - Via_In3_polyres_li1.__virtual_Via_In3_polyres_li1
*     - Via_In3_polyres_li1_1.__virtual_Via_In3_polyres_li1_1
*     - Via_In3_polyres_li1_2.__virtual_Via_In3_polyres_li1_2
*     - Via_In3_li1_metal1.__virtual_Via_In3_li1_metal1
*     - Via_In3_li1_metal1_1.__virtual_Via_In3_li1_metal1_1
*     - Via_In3_li1_metal1_2.__virtual_Via_In3_li1_metal1_2
* Net: Out3 (width=300nm, material=Aluminum)
*   Connected pins:
*     - Contact_B_LI.anchor
*     - Contact_B_LI.__virtual_Contact_B_LI
*     - Contact_B_Metal.anchor
*     - Contact_B_Metal.__virtual_Contact_B_Metal
*     - Via_Out3_polyres_li1.__virtual_Via_Out3_polyres_li1
*     - Via_Out3_polyres_li1_1.__virtual_Via_Out3_polyres_li1_1
*     - Via_Out3_polyres_li1_2.__virtual_Via_Out3_polyres_li1_2
*     - Via_Out3_li1_metal1.__virtual_Via_Out3_li1_metal1
*     - Via_Out3_li1_metal1_1.__virtual_Via_Out3_li1_metal1_1
*     - Via_Out3_li1_metal1_2.__virtual_Via_Out3_li1_metal1_2
* Net: GND (width=300nm, material=Aluminum)
*   Connected pins:
*     - Bulk_Tap_Diff.anchor
*     - Bulk_Tap_Diff.__virtual_Bulk_Tap_Diff
*     - Bulk_Tap_LI.anchor
*     - Bulk_Tap_LI.__virtual_Bulk_Tap_LI
*     - Bulk_Tap_Metal.anchor
*     - Bulk_Tap_Metal.__virtual_Bulk_Tap_Metal
*     - Bulk_Tap_Diff.anchor
*     - Bulk_Tap_Diff.__virtual_Bulk_Tap_Diff
*     - Bulk_Tap_LI.anchor
*     - Bulk_Tap_LI.__virtual_Bulk_Tap_LI
*     - Bulk_Tap_Metal.anchor
*     - Bulk_Tap_Metal.__virtual_Bulk_Tap_Metal
*     - Bulk_Tap_Diff.anchor
*     - Bulk_Tap_Diff.__virtual_Bulk_Tap_Diff
*     - Bulk_Tap_LI.anchor
*     - Bulk_Tap_LI.__virtual_Bulk_Tap_LI
*     - Bulk_Tap_Metal.anchor
*     - Bulk_Tap_Metal.__virtual_Bulk_Tap_Metal
*     - GND_Bus.anchor
*     - GND_Bus.__virtual_GND_Bus
*     - Bulk_Tap_Contact.__virtual_Bulk_Tap_Contact
*     - Bulk_Tap_Via.__virtual_Bulk_Tap_Via
*     - Bulk_Tap_Contact.__virtual_Bulk_Tap_Contact
*     - Bulk_Tap_Via.__virtual_Bulk_Tap_Via
*     - Bulk_Tap_Contact.__virtual_Bulk_Tap_Contact
*     - Bulk_Tap_Via.__virtual_Bulk_Tap_Via

* ========================================
* EXTRACTED DEVICES
* ========================================
XR1 nIn1_li1 nOut1_li1 nGND_pdiff_0 sky130_fd_pr__res_high_po W=2.85u L=3.20u
XR2 nIn2_li1 nOut2_li1 nGND_pdiff_0 sky130_fd_pr__res_high_po W=1.41u L=3.20u
XR3 nIn3_li1 nOut3_li1 nGND_pdiff_0 sky130_fd_pr__res_high_po W=0.69u L=3.20u

* ========================================
* INTEGRATED TRACE PARASITICS
* ========================================
* Via/Contact resistance
Rvia_In1_li1_metal1 nIn1_metal1 nIn1_li1 1.153403e1
* Via/Contact resistance
Rvia_In3_li1_metal1 nIn3_metal1 nIn3_li1 1.153403e1
* Via/Contact resistance
Rvia_In2_li1_metal1 nIn2_metal1 nIn2_li1 1.153403e1
* Via/Contact resistance
Rvia_Out2_li1_metal1 nOut2_metal1 nOut2_li1 1.153403e1
* Via/Contact resistance
Rvia_Out1_li1_metal1 nOut1_metal1 nOut1_li1 1.153403e1
* Via/Contact resistance
Rvia_Out3_li1_metal1 nOut3_metal1 nOut3_li1 1.153403e1
* Via/Contact resistance
Rvia_GND_li1_metal1_0 nGND_metal1_0 nGND_li1_0 3.460208e1
* Via/Contact resistance
Rvia_GND_pdiff_li1_0 nGND_li1_0 nGND_pdiff_0 3.460208e1
* Via/Contact resistance
Rvia_GND_li1_metal1_1 nGND_metal1_1 nGND_li1_1 3.460208e1
* Via/Contact resistance
Rvia_GND_pdiff_li1_1 nGND_li1_1 nGND_pdiff_1 3.460208e1
* Via/Contact resistance
Rvia_GND_li1_metal1_2 nGND_metal1_2 nGND_li1_2 3.460208e1
* Via/Contact resistance
Rvia_GND_pdiff_li1_2 nGND_li1_2 nGND_pdiff_2 3.460208e1
* Ground capacitance
Cgnd_pour_Contact_A_Metal nIn1_metal1 GND 2.624381e-16
* Ground capacitance
Cgnd_pour_Contact_B_Metal nOut1_metal1 GND 2.624381e-16
* Ground capacitance
Cgnd_pour_Contact_A_Metal nIn2_metal1 GND 1.298378e-16
* Ground capacitance
Cgnd_pour_Contact_B_Metal nOut2_metal1 GND 1.298378e-16
* Ground capacitance
Cgnd_pour_Contact_A_Metal nIn3_metal1 GND 6.353765e-17
* Ground capacitance
Cgnd_pour_Contact_B_Metal nOut3_metal1 GND 6.353765e-17
* Trace resistance
Rbus_GND_Bus_0 nGND_metal1_0 nGND_metal1_1 1.044444e0
* Trace resistance
Rbus_GND_Bus_1 nGND_metal1_1 nGND_metal1_2 1.044444e0
* Trace resistance
Rbus_GND_Bus_to_GND nGND_metal1_2 GND 1.305556e-1

* Total parasitic elements: 21

.end
