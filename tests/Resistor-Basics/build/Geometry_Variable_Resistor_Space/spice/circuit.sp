* Hardware Script Pure Circuit (DUT)
* Space: Geometry_Variable_Resistor_Space
* Generated by hwc v0.3.1
* Format: SPICE3

* ========================================
* FOUNDRY PDK MODEL INCLUDES
* ========================================
.include "sky130_fd_pr/models/sky130_fd_pr__res_high_po.model.spice"

* ========================================
* NETS
* ========================================
* Net: In1 (pour: sky130_res_high_po_polyres, material: Polysilicon, z: 200nm)
* Net: In1 (pour: sky130_res_high_po_psdm, material: P_Plus_Implant_Mask, z: 0nm)
* Net: In1 (pour: sky130_res_high_po_npc, material: Npc_Mask, z: 380nm)
* Net: Out1 (pour: sky130_res_high_po_npc, material: Npc_Mask, z: 380nm)
* Net: In1 (pour: sky130_res_high_po_li1, material: Titanium_Nitride, z: 580nm)
* Net: In1 (pour: sky130_res_high_po_metal1, material: Aluminum, z: 830nm)
* Net: Out1 (pour: sky130_res_high_po_li1, material: Titanium_Nitride, z: 580nm)
* Net: Out1 (pour: sky130_res_high_po_metal1, material: Aluminum, z: 830nm)
* Net: GND (pour: sky130_res_high_po_tap, material: Tap_Mask, z: 0nm)
* Net: GND (pour: sky130_res_high_po_psdm, material: P_Plus_Implant_Mask, z: 0nm)
* Net: GND (pour: sky130_res_high_po_pdiff, material: P_Plus_Diffusion, z: 0nm)
* Net: GND (pour: sky130_res_high_po_li1, material: Titanium_Nitride, z: 580nm)
* Net: GND (pour: sky130_res_high_po_metal1, material: Aluminum, z: 830nm)
* Net: In2 (pour: sky130_res_high_po_1_polyres, material: Polysilicon, z: 200nm)
* Net: In2 (pour: sky130_res_high_po_1_psdm, material: P_Plus_Implant_Mask, z: 0nm)
* Net: In2 (pour: sky130_res_high_po_1_npc, material: Npc_Mask, z: 380nm)
* Net: Out2 (pour: sky130_res_high_po_1_npc, material: Npc_Mask, z: 380nm)
* Net: In2 (pour: sky130_res_high_po_1_li1, material: Titanium_Nitride, z: 580nm)
* Net: In2 (pour: sky130_res_high_po_1_metal1, material: Aluminum, z: 830nm)
* Net: Out2 (pour: sky130_res_high_po_1_li1, material: Titanium_Nitride, z: 580nm)
* Net: Out2 (pour: sky130_res_high_po_1_metal1, material: Aluminum, z: 830nm)
* Net: GND (pour: sky130_res_high_po_1_tap, material: Tap_Mask, z: 0nm)
* Net: GND (pour: sky130_res_high_po_1_psdm, material: P_Plus_Implant_Mask, z: 0nm)
* Net: GND (pour: sky130_res_high_po_1_pdiff, material: P_Plus_Diffusion, z: 0nm)
* Net: GND (pour: sky130_res_high_po_1_li1, material: Titanium_Nitride, z: 580nm)
* Net: GND (pour: sky130_res_high_po_1_metal1, material: Aluminum, z: 830nm)
* Net: In3 (pour: sky130_res_high_po_2_polyres, material: Polysilicon, z: 200nm)
* Net: In3 (pour: sky130_res_high_po_2_psdm, material: P_Plus_Implant_Mask, z: 0nm)
* Net: In3 (pour: sky130_res_high_po_2_npc, material: Npc_Mask, z: 380nm)
* Net: Out3 (pour: sky130_res_high_po_2_npc, material: Npc_Mask, z: 380nm)
* Net: In3 (pour: sky130_res_high_po_2_li1, material: Titanium_Nitride, z: 580nm)
* Net: In3 (pour: sky130_res_high_po_2_metal1, material: Aluminum, z: 830nm)
* Net: Out3 (pour: sky130_res_high_po_2_li1, material: Titanium_Nitride, z: 580nm)
* Net: Out3 (pour: sky130_res_high_po_2_metal1, material: Aluminum, z: 830nm)
* Net: GND (pour: sky130_res_high_po_2_tap, material: Tap_Mask, z: 0nm)
* Net: GND (pour: sky130_res_high_po_2_psdm, material: P_Plus_Implant_Mask, z: 0nm)
* Net: GND (pour: sky130_res_high_po_2_pdiff, material: P_Plus_Diffusion, z: 0nm)
* Net: GND (pour: sky130_res_high_po_2_li1, material: Titanium_Nitride, z: 580nm)
* Net: GND (pour: sky130_res_high_po_2_metal1, material: Aluminum, z: 830nm)
* Net: In1 (pour: pad_3_metal1, material: Aluminum, z: 830nm)
* Net: In1 (pour: pad_3_pad, material: Pad_Mask, z: 1.19µm)
* Net: Out1 (pour: pad_4_metal1, material: Aluminum, z: 830nm)
* Net: Out1 (pour: pad_4_pad, material: Pad_Mask, z: 1.19µm)
* Net: In2 (pour: pad_5_metal1, material: Aluminum, z: 830nm)
* Net: In2 (pour: pad_5_pad, material: Pad_Mask, z: 1.19µm)
* Net: Out2 (pour: pad_6_metal1, material: Aluminum, z: 830nm)
* Net: Out2 (pour: pad_6_pad, material: Pad_Mask, z: 1.19µm)
* Net: In3 (pour: pad_7_metal1, material: Aluminum, z: 830nm)
* Net: In3 (pour: pad_7_pad, material: Pad_Mask, z: 1.19µm)
* Net: Out3 (pour: pad_8_metal1, material: Aluminum, z: 830nm)
* Net: Out3 (pour: pad_8_pad, material: Pad_Mask, z: 1.19µm)
* Net: GND (pour: pad_9_metal1, material: Aluminum, z: 830nm)
* Net: GND (pour: pad_9_pad, material: Pad_Mask, z: 1.19µm)
* Net: In1 (width=300nm, material=P_Plus_Diffusion)
* Net: Out1 (width=300nm, material=P_Plus_Diffusion)
* Net: In2 (width=300nm, material=P_Plus_Diffusion)
* Net: Out2 (width=300nm, material=P_Plus_Diffusion)
* Net: In3 (width=300nm, material=P_Plus_Diffusion)
* Net: Out3 (width=300nm, material=P_Plus_Diffusion)
* Net: GND (width=300nm, material=P_Plus_Diffusion)

* ========================================
* EXTRACTED DEVICES
* ========================================
Xsky130_res_high_po nIn1_li1_0 nOut1_li1 nGND_pdiff_0 sky130_fd_pr__res_high_po w=2.85u l=4.00u
Xsky130_res_high_po_1 nIn2_li1_0 nOut2_li1 nGND_pdiff_1 sky130_fd_pr__res_high_po w=1.41u l=4.00u
Xsky130_res_high_po_2 nIn3_li1_0 nOut3_li1 nGND_pdiff_2 sky130_fd_pr__res_high_po w=0.69u l=4.00u

* ========================================
* INTEGRATED TRACE PARASITICS
* ========================================
* Via/Contact resistance
Rvia_In1_li1_metal1_0 nIn1_metal1_0 nIn1_li1_0 8.650519e0
* Via/Contact resistance
Rvia_In3_li1_metal1_0 nIn3_metal1_0 nIn3_li1_0 3.460208e1
* Via/Contact resistance
Rvia_In2_li1_metal1_0 nIn2_metal1_0 nIn2_li1_0 1.730104e1
* Via/Contact resistance
Rvia_Out2_li1_metal1 nOut2_metal1 nOut2_li1 1.730104e1
* Via/Contact resistance
Rvia_Out1_li1_metal1 nOut1_metal1 nOut1_li1 8.650519e0
* Via/Contact resistance
Rvia_Out3_li1_metal1 nOut3_metal1 nOut3_li1 3.460208e1
* Via/Contact resistance
Rvia_GND_li1_metal1_0 nGND_metal1_0 nGND_li1_0 3.460208e1
* Via/Contact resistance
Rvia_GND_pdiff_li1_0 nGND_li1_0 nGND_pdiff_0 3.460208e1
* Via/Contact resistance
Rvia_GND_li1_metal1_1 nGND_metal1_1 nGND_li1_1 3.460208e1
* Via/Contact resistance
Rvia_GND_pdiff_li1_1 nGND_li1_1 nGND_pdiff_1 3.460208e1
* Via/Contact resistance
Rvia_GND_li1_metal1_2 nGND_metal1_2 nGND_li1_2 3.460208e1
* Via/Contact resistance
Rvia_GND_pdiff_li1_2 nGND_li1_2 nGND_pdiff_2 3.460208e1
* Trace resistance
Rtr_In1_0_0 nIn1_pad nIn1_metal1_0 9.333333e-1
* Ground capacitance
Cgnd_In1_0_0 nIn1_metal1_0 GND 1.547004e-16
* Trace resistance
Rtr_Out1_1_0 nOut1_metal1 nOut1_pad 9.333333e-1
* Ground capacitance
Cgnd_Out1_1_0 nOut1_pad GND 1.547004e-16
* Trace resistance
Rtr_In2_2_0 nIn2_pad nIn2_metal1_0 9.333333e-1
* Ground capacitance
Cgnd_In2_2_0 nIn2_metal1_0 GND 1.547004e-16
* Trace resistance
Rtr_Out2_3_0 nOut2_metal1 nOut2_pad 9.333333e-1
* Ground capacitance
Cgnd_Out2_3_0 nOut2_pad GND 1.547004e-16
* Trace resistance
Rtr_In3_4_0 nIn3_pad nIn3_metal1_0 9.333333e-1
* Ground capacitance
Cgnd_In3_4_0 nIn3_metal1_0 GND 1.547004e-16
* Trace resistance
Rtr_Out3_5_0 nOut3_metal1 nOut3_pad 9.333333e-1
* Ground capacitance
Cgnd_Out3_5_0 nOut3_pad GND 1.547004e-16
* Trace resistance
Rtr_GND_6_0 nGND_metal1_0 nGND_metal1_1 5.000000e0
* Trace resistance
Rtr_GND_7_0 nGND_metal1_1 nGND_metal1_2 5.000000e0
* Trace resistance
Rtr_GND_8_0 nGND_metal1_1 nGND_pad 2.291667e0
* Lateral coupling capacitance
Cc_Out1_GND_1_6 nOut1_metal1_tr1_end nGND_metal1_1 5.133240e-17
* Lateral coupling capacitance
Cc_In2_GND_2_6 nIn2_metal1_0 nGND_metal1_1 5.133240e-17
* Lateral coupling capacitance
Cc_Out2_GND_3_7 nOut2_metal1_tr3_end nGND_metal1_2 5.133240e-17
* Lateral coupling capacitance
Cc_In3_GND_4_7 nIn3_metal1_0 nGND_metal1_2 5.133240e-17
* Ground capacitance
Cgnd_pour_pad_3_metal1 nIn1_pad GND 1.664161e-16
* Ground capacitance
Cgnd_pour_pad_4_metal1 nOut1_pad GND 1.664161e-16
* Ground capacitance
Cgnd_pour_pad_5_metal1 nIn2_pad GND 1.664161e-16
* Ground capacitance
Cgnd_pour_pad_6_metal1 nOut2_pad GND 1.664161e-16
* Ground capacitance
Cgnd_pour_pad_7_metal1 nIn3_pad GND 1.664161e-16
* Ground capacitance
Cgnd_pour_pad_8_metal1 nOut3_pad GND 1.664161e-16
* Trace resistance
Rpad_stimulus_bridge_In1 In1 nIn1_pad 1.000000e-4
* Trace resistance
Rpad_stimulus_bridge_Out1 Out1 nOut1_pad 1.000000e-4
* Trace resistance
Rpad_stimulus_bridge_In2 In2 nIn2_pad 1.000000e-4
* Trace resistance
Rpad_stimulus_bridge_Out2 Out2 nOut2_pad 1.000000e-4
* Trace resistance
Rpad_stimulus_bridge_In3 In3 nIn3_pad 1.000000e-4
* Trace resistance
Rpad_stimulus_bridge_Out3 Out3 nOut3_pad 1.000000e-4
* Trace resistance
Rpad_stimulus_bridge_GND GND nGND_pad 1.000000e-4

* Total parasitic elements: 44

.end
