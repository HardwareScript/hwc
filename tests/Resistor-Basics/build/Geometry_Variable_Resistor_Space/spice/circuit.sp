* Hardware Script Pure Circuit (DUT)
* Space: Geometry_Variable_Resistor_Space
* Generated by hwc v0.2.1
* Format: SPICE3

* ========================================
* PDK SUBCIRCUIT: sky130_fd_pr__res_high_po
* ========================================
* Subcircuit 'sky130_fd_pr__res_high_po' uses foundry model
.include "sky130_fd_pr/models/sky130_fd_pr__res_high_po.model.spice"

* ========================================
* NETS
* ========================================
* Net: In1 (pour: R1_Contact_A_LI, material: Titanium_Silicide, z: 380nm)
* Net: Out1 (pour: R1_Contact_B_LI, material: Titanium_Silicide, z: 380nm)
* Net: In1 (pour: R1_Contact_A_Metal, material: Aluminum, z: 630nm)
* Net: Out1 (pour: R1_Contact_B_Metal, material: Aluminum, z: 630nm)
* Net: In2 (pour: R2_Contact_A_LI, material: Titanium_Silicide, z: 380nm)
* Net: Out2 (pour: R2_Contact_B_LI, material: Titanium_Silicide, z: 380nm)
* Net: In2 (pour: R2_Contact_A_Metal, material: Aluminum, z: 630nm)
* Net: Out2 (pour: R2_Contact_B_Metal, material: Aluminum, z: 630nm)
* Net: In3 (pour: R3_Contact_A_LI, material: Titanium_Silicide, z: 380nm)
* Net: Out3 (pour: R3_Contact_B_LI, material: Titanium_Silicide, z: 380nm)
* Net: In3 (pour: R3_Contact_A_Metal, material: Aluminum, z: 630nm)
* Net: Out3 (pour: R3_Contact_B_Metal, material: Aluminum, z: 630nm)
* Net: In1 (width=300nm, material=Tungsten)
*   Connected pins:
*     - R1_Contact_A_LI.anchor
*     - R1_Contact_A_LI.__virtual_R1_Contact_A_LI
*     - R1_Via_A_Poly.__virtual_R1_Via_A_Poly
*     - R1_Contact_A_Metal.anchor
*     - R1_Contact_A_Metal.__virtual_R1_Contact_A_Metal
*     - R1_Via_A_Metal.__virtual_R1_Via_A_Metal
* Net: Out1 (width=300nm, material=Tungsten)
*   Connected pins:
*     - R1_Contact_B_LI.anchor
*     - R1_Contact_B_LI.__virtual_R1_Contact_B_LI
*     - R1_Via_B_Poly.__virtual_R1_Via_B_Poly
*     - R1_Contact_B_Metal.anchor
*     - R1_Contact_B_Metal.__virtual_R1_Contact_B_Metal
*     - R1_Via_B_Metal.__virtual_R1_Via_B_Metal
* Net: In2 (width=300nm, material=Tungsten)
*   Connected pins:
*     - R2_Contact_A_LI.anchor
*     - R2_Contact_A_LI.__virtual_R2_Contact_A_LI
*     - R2_Via_A_Poly.__virtual_R2_Via_A_Poly
*     - R2_Contact_A_Metal.anchor
*     - R2_Contact_A_Metal.__virtual_R2_Contact_A_Metal
*     - R2_Via_A_Metal.__virtual_R2_Via_A_Metal
* Net: Out2 (width=300nm, material=Tungsten)
*   Connected pins:
*     - R2_Contact_B_LI.anchor
*     - R2_Contact_B_LI.__virtual_R2_Contact_B_LI
*     - R2_Via_B_Poly.__virtual_R2_Via_B_Poly
*     - R2_Contact_B_Metal.anchor
*     - R2_Contact_B_Metal.__virtual_R2_Contact_B_Metal
*     - R2_Via_B_Metal.__virtual_R2_Via_B_Metal
* Net: In3 (width=300nm, material=Tungsten)
*   Connected pins:
*     - R3_Contact_A_LI.anchor
*     - R3_Contact_A_LI.__virtual_R3_Contact_A_LI
*     - R3_Via_A_Poly.__virtual_R3_Via_A_Poly
*     - R3_Contact_A_Metal.anchor
*     - R3_Contact_A_Metal.__virtual_R3_Contact_A_Metal
*     - R3_Via_A_Metal.__virtual_R3_Via_A_Metal
* Net: Out3 (width=300nm, material=Tungsten)
*   Connected pins:
*     - R3_Contact_B_LI.anchor
*     - R3_Contact_B_LI.__virtual_R3_Contact_B_LI
*     - R3_Via_B_Poly.__virtual_R3_Via_B_Poly
*     - R3_Contact_B_Metal.anchor
*     - R3_Contact_B_Metal.__virtual_R3_Contact_B_Metal
*     - R3_Via_B_Metal.__virtual_R3_Via_B_Metal
* Net: GND (width=300nm, material=Tungsten)

* ========================================
* EXTRACTED DEVICES
* ========================================
XR2 In2 Out2 GND sky130_fd_pr__res_high_po W=1.00u L=4.00u
XR3 In3 Out3 GND sky130_fd_pr__res_high_po W=0.50u L=4.00u
XR1 In1 Out1 GND sky130_fd_pr__res_high_po W=4.00u L=4.00u

.end
