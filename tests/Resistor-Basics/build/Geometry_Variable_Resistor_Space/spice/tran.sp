* Hardware Script Transient Waveform Test
* Space: Geometry_Variable_Resistor_Space
* Generated by hwc v0.3.1
* Format: SPICE3

.include "circuit.sp"

* ========================================
* STIMULUS & ANALYSIS
* ========================================
V_In1 In1 0 PULSE(0.0000e0 1.8000e0 0.000e0 1.000e-10 1.000e-10 1.000e-7 2.000e-7)
V_In2 In2 0 PULSE(0.0000e0 1.8000e0 0.000e0 1.000e-10 1.000e-10 5.000e-8 1.000e-7)
V_In3 In3 0 PULSE(0.0000e0 1.8000e0 0.000e0 1.000e-10 1.000e-10 2.500e-8 5.000e-8)
V_GND GND 0 DC 0.0000e0
I_load_Out1 Out1 0 DC 1.0000e-6
I_load_Out2 Out2 0 DC 1.0000e-6
I_load_Out3 Out3 0 DC 1.0000e-6
.tran 1.000e-11 2.000e-7
.end
