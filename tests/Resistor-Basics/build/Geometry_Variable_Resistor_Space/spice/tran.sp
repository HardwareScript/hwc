* Hardware Script Transient Waveform Test
* Space: Geometry_Variable_Resistor_Space
* Generated by hwc v0.2.1
* Format: SPICE3

.include "circuit.sp"

* ========================================
* STIMULUS & ANALYSIS
* ========================================
V_In1 In1 0 PULSE(0.0 1.800 0.0 1.000e-10 1.000e-10 1.000e-7 2.000e-7)
V_In2 In2 0 DC 1.800
V_In3 In3 0 DC 1.800
V_GND GND 0 DC 0.000
.tran 1.000e-11 2.000e-7
.end
