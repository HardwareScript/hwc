* Hardware Script AC Frequency Response Test
* Space: Geometry_Variable_Resistor_Space
* Generated by hwc v0.2.1
* Format: SPICE3

.include "circuit.sp"

* ========================================
* STIMULUS & ANALYSIS
* ========================================
V_In1 In1 0 DC 1.800 AC 1.0
V_In2 In2 0 DC 1.800
V_In3 In3 0 DC 1.800
V_GND GND 0 DC 0.000
* AC Small-Signal Frequency Response (Configured via Testbench)
.ac dec 20 1.000e2 1.000e8
* Frequency range configured from testbench 'ac:' block
.end
