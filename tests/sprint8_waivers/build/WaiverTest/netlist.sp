* Hardware Script Native Netlist: WaiverTest
* Generated by hwc v0.1.6 (Syntax Unification)
* Format: SPICE3

* ========================================
* COMPONENTS
* ========================================
XM1_Waived nc_0 nc_1 nc_2 nc_3 Transistor
XM2_Floating nc_4 nc_5 nc_6 nc_7 Transistor
XFingerArray[0] nc_8 nc_9 nc_10 nc_11 Transistor
XFingerArray[1] nc_12 nc_13 nc_14 nc_15 Transistor
XFingerArray[2] nc_16 nc_17 nc_18 nc_19 Transistor
XM3_Surgical nc_20 nc_21 nc_22 nc_23 Transistor
XM3_Target nc_24 nc_25 nc_26 nc_27 Transistor

* ========================================
* DEVICE EXTRACTION REQUIRES EXPLICIT BINDINGS
* Use 'device: DeviceName.terminal' property
* ========================================

.end
