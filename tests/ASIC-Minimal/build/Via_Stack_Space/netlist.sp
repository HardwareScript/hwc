* Hardware Script Native Netlist: Via_Stack_Space
* Generated by hwc v0.1.6 (Syntax Unification)
* Format: SPICE3

* ========================================
* NETS
* ========================================
* Net: Signal (pour: Poly_Strip, material: Polysilicon, z: 0.0004mm)
* Net: Signal (pour: Metal_Pad, material: Aluminum, z: 0.0013mm)
* Net: Signal (width=200nm, material=Tungsten)
*   Connected pins:
*     - Poly_Strip.__virtual_Poly_Strip
*     - Metal_Pad.__virtual_Metal_Pad
*     - Test_Via.__virtual_Test_Via

* ========================================
* AUTOMATIC STIMULUS & MODELS
* ========================================
Vgnd GND 0 0
.end
