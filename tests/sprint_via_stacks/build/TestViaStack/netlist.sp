* Hardware Script Native Netlist: TestViaStack
* Generated by hwc v0.1.6 (Syntax Unification)
* Format: SPICE3

* ========================================
* NETS
* ========================================
* Net: VDD (pour: VDD_Bottom, material: Copper, layer: 1)
* Net: VDD (pour: VDD_Top, material: Copper, layer: 10)

* ========================================
* COMPONENTS
* ========================================
XVDD_Bottom VDD Pour(Copper)
XVDD_Top VDD Pour(Copper)
XAutoVia_VDD_1_2 VDD Contact(Copper)
XAutoVia_VDD_2_3 VDD Contact(Copper)
XAutoVia_VDD_3_4 VDD Contact(Copper)
XAutoVia_VDD_4_5 VDD Contact(Copper)
XAutoVia_VDD_5_6 VDD Contact(Copper)
XAutoVia_VDD_6_7 VDD Contact(Copper)
XAutoVia_VDD_7_8 VDD Contact(Copper)
XAutoVia_VDD_8_9 VDD Contact(Copper)
XAutoVia_VDD_9_10 VDD Contact(Copper)

.end
