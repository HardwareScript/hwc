* Hardware Script Native Netlist: TestViaDiameter
* Generated by hwc v0.1.6 (Syntax Unification)
* Format: SPICE3

* ========================================
* NETS
* ========================================
* Net: Signal (pour: BottomPad, material: Copper, layer: 5)
* Net: Signal (pour: TopPad, material: Copper, layer: 15)

* ========================================
* COMPONENTS
* ========================================
XBottomPad Signal Pour(Copper)
XTopPad Signal Pour(Copper)
XSmallVia Signal Contact(Copper)

* ========================================
* DEVICE EXTRACTION REQUIRES EXPLICIT BINDINGS
* Use 'device: DeviceName.terminal' property
* ========================================

.end
