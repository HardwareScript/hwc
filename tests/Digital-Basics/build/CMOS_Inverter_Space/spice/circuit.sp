* Hardware Script Pure Circuit (DUT)
* Space: CMOS_Inverter_Space
* Generated by hwc v0.3.1
* Format: SPICE3

* ========================================
* FOUNDRY PDK MODEL INCLUDES
* ========================================
.include "sky130_fd_pr/models/sky130_fd_pr__nfet_01v8.model.spice"
.include "sky130_fd_pr/models/sky130_fd_pr__pfet_01v8.model.spice"

* ========================================
* NETS
* ========================================
* Net: Out (pour: sky130_nmos_diff, material: N_Plus_Diffusion, z: 0nm)
* Net: Out (pour: sky130_nmos_nsdm, material: N_Plus_Implant_Mask, z: 0nm)
* Net: In (pour: sky130_nmos_poly, material: Polysilicon, z: 200nm)
* Net: In (pour: sky130_nmos_npc, material: Npc_Mask, z: 380nm)
* Net: In (pour: sky130_nmos_li1, material: Titanium_Nitride, z: 580nm)
* Net: In (pour: sky130_nmos_metal1, material: Aluminum, z: 830nm)
* Net: VSS (pour: sky130_nmos_li1, material: Titanium_Nitride, z: 580nm)
* Net: VSS (pour: sky130_nmos_metal1, material: Aluminum, z: 830nm)
* Net: Out (pour: sky130_nmos_li1, material: Titanium_Nitride, z: 580nm)
* Net: Out (pour: sky130_nmos_metal1, material: Aluminum, z: 830nm)
* Net: Out (pour: sky130_pmos_1_nwell, material: N_Well, z: 0nm)
* Net: Out (pour: sky130_pmos_1_diff, material: N_Plus_Diffusion, z: 0nm)
* Net: Out (pour: sky130_pmos_1_psdm, material: P_Plus_Implant_Mask, z: 0nm)
* Net: In (pour: sky130_pmos_1_poly, material: Polysilicon, z: 200nm)
* Net: In (pour: sky130_pmos_1_npc, material: Npc_Mask, z: 380nm)
* Net: In (pour: sky130_pmos_1_li1, material: Titanium_Nitride, z: 580nm)
* Net: In (pour: sky130_pmos_1_metal1, material: Aluminum, z: 830nm)
* Net: VDD (pour: sky130_pmos_1_li1, material: Titanium_Nitride, z: 580nm)
* Net: VDD (pour: sky130_pmos_1_metal1, material: Aluminum, z: 830nm)
* Net: Out (pour: sky130_pmos_1_li1, material: Titanium_Nitride, z: 580nm)
* Net: Out (pour: sky130_pmos_1_metal1, material: Aluminum, z: 830nm)
* Net: VSS (pour: sky130_tap_2_tap, material: Tap_Mask, z: 0nm)
* Net: VSS (pour: sky130_tap_2_psdm, material: P_Plus_Implant_Mask, z: 0nm)
* Net: VSS (pour: sky130_tap_2_diff, material: N_Plus_Diffusion, z: 0nm)
* Net: VSS (pour: sky130_tap_2_li1, material: Titanium_Nitride, z: 580nm)
* Net: VSS (pour: sky130_tap_2_metal1, material: Aluminum, z: 830nm)
* Net: VDD (pour: sky130_tap_3_tap, material: Tap_Mask, z: 0nm)
* Net: VDD (pour: sky130_tap_3_nsdm, material: N_Plus_Implant_Mask, z: 0nm)
* Net: VDD (pour: sky130_tap_3_diff, material: N_Plus_Diffusion, z: 0nm)
* Net: VDD (pour: sky130_tap_3_li1, material: Titanium_Nitride, z: 580nm)
* Net: VDD (pour: sky130_tap_3_metal1, material: Aluminum, z: 830nm)
* Net: In (pour: pad_4_metal1, material: Aluminum, z: 830nm)
* Net: In (pour: pad_4_pad, material: Pad_Mask, z: 1.19µm)
* Net: Out (pour: pad_5_metal1, material: Aluminum, z: 830nm)
* Net: Out (pour: pad_5_pad, material: Pad_Mask, z: 1.19µm)
* Net: VDD (pour: pad_6_metal1, material: Aluminum, z: 830nm)
* Net: VDD (pour: pad_6_pad, material: Pad_Mask, z: 1.19µm)
* Net: VSS (pour: pad_7_metal1, material: Aluminum, z: 830nm)
* Net: VSS (pour: pad_7_pad, material: Pad_Mask, z: 1.19µm)
* Net: VDD (width=300nm, material=N_Plus_Diffusion)
* Net: VSS (width=300nm, material=N_Plus_Diffusion)
* Net: In (width=300nm, material=N_Plus_Diffusion)
* Net: Out (width=300nm, material=N_Plus_Diffusion)

* ========================================
* EXTRACTED DEVICES
* ========================================
Xsky130_nmos nOut_metal1_2 nIn_metal1_0 nVSS_metal1_1  sky130_fd_pr__nfet_01v8 w=1.00u l=0.15u
Xsky130_pmos_1 nOut_metal1_3 nIn_metal1_1 nVDD_metal1_1  sky130_fd_pr__pfet_01v8 w=2.00u l=0.15u

* ========================================
* INTEGRATED TRACE PARASITICS
* ========================================
* Via/Contact resistance
Rvia_VDD_diff_li1_0 nVDD_li1_0 nVDD_diff_0 3.460208e1
* Via/Contact resistance
Rvia_VDD_li1_metal1_0 nVDD_metal1_0 nVDD_li1_0 3.460208e1
* Via/Contact resistance
Rvia_VDD_li1_metal1_1 nVDD_metal1_1 nVDD_li1_1 8.650519e0
* Via/Contact resistance
Rvia_VSS_diff_li1_0 nVSS_li1_0 nVSS_diff_0 3.460208e1
* Via/Contact resistance
Rvia_VSS_li1_metal1_0 nVSS_metal1_0 nVSS_li1_0 3.460208e1
* Via/Contact resistance
Rvia_VSS_li1_metal1_1 nVSS_metal1_1 nVSS_li1_1 1.730104e1
* Via/Contact resistance
Rvia_In_li1_metal1_0 nIn_metal1_0 nIn_li1_0 3.460208e1
* Via/Contact resistance
Rvia_In_li1_metal1_1 nIn_metal1_1 nIn_li1_1 3.460208e1
* Via/Contact resistance
Rvia_Out_diff_li1_0 nOut_li1_0 nOut_diff_0 1.730104e1
* Via/Contact resistance
Rvia_Out_diff_li1_1 nOut_li1_1 nOut_diff_1 8.650519e0
* Via/Contact resistance
Rvia_Out_diff_li1_2 nOut_li1_2 nOut_diff_2 1.730104e1
* Via/Contact resistance
Rvia_Out_li1_metal1_2 nOut_metal1_2 nOut_li1_2 1.730104e1
* Via/Contact resistance
Rvia_Out_diff_li1_3 nOut_li1_3 nOut_diff_3 8.650519e0
* Via/Contact resistance
Rvia_Out_li1_metal1_3 nOut_metal1_3 nOut_li1_3 8.650519e0
* Trace resistance
Rtr_In_0_0 nIn_metal1_0 nIn_metal1_1 1.570833e1
* Ground capacitance
Cgnd_In_0_0 nIn_metal1_1 VSS 2.603662e-15
* Trace resistance
Rtr_In_1_0 nIn_pad nIn_metal1_0 3.023292e1
* Ground capacitance
Cgnd_In_1_0 nIn_metal1_0 VSS 5.011119e-15
* Trace resistance
Rtr_Out_2_0 nOut_metal1_2 nOut_metal1_3 1.666667e1
* Ground capacitance
Cgnd_Out_2_0 nOut_metal1_3 VSS 2.762507e-15
* Trace resistance
Rtr_Out_3_0 nOut_metal1_3 nOut_pad 3.015355e1
* Ground capacitance
Cgnd_Out_3_0 nOut_pad VSS 4.997963e-15
* Trace resistance
Rtr_VDD_4_0 nVDD_pad nVDD_metal1_1 8.750723e0
* Ground capacitance
Cgnd_VDD_4_0 nVDD_metal1_1 VSS 4.028988e-15
* Trace resistance
Rtr_VDD_5_0 nVDD_metal1_1 nVDD_metal1_0 8.875000e-1
* Ground capacitance
Cgnd_VDD_5_0 nVDD_metal1_0 VSS 4.086208e-16
* Trace resistance
Rtr_VSS_6_0 nVSS_pad nVSS_metal1_1 8.750723e0
* Trace resistance
Rtr_VSS_7_0 nVSS_metal1_1 nVSS_metal1_0 8.875000e-1
* Lateral coupling capacitance
Cc_In_Out_0_2 nIn_metal1_1 nOut_metal1_3 3.775311e-15
* Trace resistance
Rbus_sky130_nmos_diff_diff_h_0_0 nOut_diff_0 nOut_diff_2 1.773000e2
* Trace resistance
Rbus_sky130_pmos_1_diff_diff_h_0_0 nOut_diff_1 nOut_diff_3 8.865000e1
* Ground capacitance
Cgnd_pour_pad_4_metal1 nIn_pad VSS 6.656642e-14
* Ground capacitance
Cgnd_pour_pad_5_metal1 nOut_pad VSS 6.656642e-14
* Ground capacitance
Cgnd_pour_pad_6_metal1 nVDD_pad VSS 6.656642e-14
* Trace resistance
Rpad_stimulus_bridge_In In nIn_pad 1.000000e-4
* Trace resistance
Rpad_stimulus_bridge_Out Out nOut_pad 1.000000e-4
* Trace resistance
Rpad_stimulus_bridge_VDD VDD nVDD_pad 1.000000e-4
* Trace resistance
Rpad_stimulus_bridge_VSS VSS nVSS_pad 1.000000e-4

* Total parasitic elements: 38

.end
