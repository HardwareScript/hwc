* Hardware Script DC Sweep Analysis Test
* Space: Simple_PMOS_Space
* Generated by hwc v0.2.1
* Format: SPICE3

.include "circuit.sp"

* ========================================
* STIMULUS & ANALYSIS
* ========================================
V_Source Source 0 DC 1.8000e0
V_Bulk Bulk 0 DC 1.8000e0
V_Gate Gate 0 DC 1.8000e0
V_Drain Drain 0 DC 0.0000e0
.dc V_Gate 1.8000e0 0.0000e0 -5.0000e-2
.end
