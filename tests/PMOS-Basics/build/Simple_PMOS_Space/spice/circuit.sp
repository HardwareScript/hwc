* Hardware Script Pure Circuit (DUT)
* Space: Simple_PMOS_Space
* Generated by hwc v0.2.1
* Format: SPICE3

* ========================================
* PDK SUBCIRCUIT: sky130_fd_pr__pfet_01v8
* ========================================
* Subcircuit 'sky130_fd_pr__pfet_01v8' uses foundry model
.include "sky130_fd_pr/models/sky130_fd_pr__pfet_01v8.model.spice"

* ========================================
* NETS
* ========================================
* Net: Gate (pour: Gate_Poly, material: Polysilicon, z: 150nm)
* Net: Gate (pour: Gate_Poly_Head, material: Polysilicon, z: 150nm)
* Net: Source (pour: Source_LI, material: Titanium_Nitride, z: 530nm)
* Net: Source (pour: Source_Metal, material: Copper, z: 780nm)
* Net: Drain (pour: Drain_LI, material: Titanium_Nitride, z: 530nm)
* Net: Drain (pour: Drain_Metal, material: Copper, z: 780nm)
* Net: Gate (pour: Gate_Contact_LI, material: Titanium_Nitride, z: 530nm)
* Net: Gate (pour: Gate_Contact_Metal, material: Copper, z: 780nm)
* Net: Bulk (pour: Bulk_Tap_Diff, material: N_Plus_Diffusion, z: 0nm)
* Net: Bulk (pour: Bulk_Tap_LI, material: Titanium_Nitride, z: 530nm)
* Net: Bulk (pour: Bulk_Tap_Metal, material: Copper, z: 780nm)
* Net: Source (pour: Source_Pad, material: Copper, z: 780nm)
* Net: Drain (pour: Drain_Pad, material: Copper, z: 780nm)
* Net: Gate (pour: Gate_Pad, material: Copper, z: 780nm)
* Net: Bulk (pour: Bulk_Pad, material: Copper, z: 780nm)
* Net: Source (width=150nm, material=Tungsten)
*   Connected pins:
*     - Source_LI.anchor
*     - Source_LI.__virtual_Source_LI
*     - Source_Metal.anchor
*     - Source_Metal.__virtual_Source_Metal
*     - Source_Via_LI_0.__virtual_Source_Via_LI_0
*     - Source_Via_M1_0.__virtual_Source_Via_M1_0
*     - Source_Via_LI_1.__virtual_Source_Via_LI_1
*     - Source_Via_M1_1.__virtual_Source_Via_M1_1
*     - Source_Pad.anchor
*     - Source_Pad.__virtual_Source_Pad
* Net: Bulk (width=150nm, material=Tungsten)
*   Connected pins:
*     - Bulk_Tap_Diff.anchor
*     - Bulk_Tap_Diff.__virtual_Bulk_Tap_Diff
*     - Bulk_Tap_LI.anchor
*     - Bulk_Tap_LI.__virtual_Bulk_Tap_LI
*     - Bulk_Tap_Metal.anchor
*     - Bulk_Tap_Metal.__virtual_Bulk_Tap_Metal
*     - Bulk_Tap_Licon.__virtual_Bulk_Tap_Licon
*     - Bulk_Tap_Mcon.__virtual_Bulk_Tap_Mcon
*     - Bulk_Pad.anchor
*     - Bulk_Pad.__virtual_Bulk_Pad
* Net: Gate (width=150nm, material=Tungsten)
*   Connected pins:
*     - Gate_Poly.anchor
*     - Gate_Poly.__virtual_Gate_Poly
*     - Gate_Poly_Head.anchor
*     - Gate_Poly_Head.__virtual_Gate_Poly_Head
*     - Gate_Contact_LI.anchor
*     - Gate_Contact_LI.__virtual_Gate_Contact_LI
*     - Gate_Contact_Metal.anchor
*     - Gate_Contact_Metal.__virtual_Gate_Contact_Metal
*     - Gate_Via_LI.__virtual_Gate_Via_LI
*     - Gate_Via_M1.__virtual_Gate_Via_M1
*     - Gate_Pad.anchor
*     - Gate_Pad.__virtual_Gate_Pad
* Net: Drain (width=150nm, material=Tungsten)
*   Connected pins:
*     - Drain_LI.anchor
*     - Drain_LI.__virtual_Drain_LI
*     - Drain_Metal.anchor
*     - Drain_Metal.__virtual_Drain_Metal
*     - Drain_Via_LI_0.__virtual_Drain_Via_LI_0
*     - Drain_Via_M1_0.__virtual_Drain_Via_M1_0
*     - Drain_Via_LI_1.__virtual_Drain_Via_LI_1
*     - Drain_Via_M1_1.__virtual_Drain_Via_M1_1
*     - Drain_Pad.anchor
*     - Drain_Pad.__virtual_Drain_Pad

* ========================================
* EXTRACTED DEVICES
* ========================================
XM1 nDrain_diff nGate_poly nSource_diff nBulk_diff sky130_fd_pr__pfet_01v8 W=1.00u L=0.15u AD=0.65p AS=0.65p PD=3.30u PS=3.30u NRD=0.65 NRS=0.65 SA=0.65u SB=0.65u

* ========================================
* INTEGRATED TRACE PARASITICS
* ========================================
* Via/Contact resistance
Rvia_Gate_poly_li1 nGate_li1 nGate_poly 1.000088e2
* Via/Contact resistance
Rvia_Gate_li1_metal1 nGate_metal1 nGate_li1 2.000176e1
* Via/Contact resistance
Rvia_Source_diff_li1 nSource_li1 nSource_diff 7.996297e1
* Via/Contact resistance
Rvia_Source_li1_metal1 nSource_metal1 nSource_li1 1.000088e1
* Via/Contact resistance
Rvia_Drain_diff_li1 nDrain_li1 nDrain_diff 7.996297e1
* Via/Contact resistance
Rvia_Drain_li1_metal1 nDrain_metal1 nDrain_li1 1.000088e1
* Via/Contact resistance
Rvia_Bulk_diff_li1 nBulk_li1 nBulk_diff 1.599259e2
* Via/Contact resistance
Rvia_Bulk_li1_metal1 nBulk_metal1 nBulk_li1 2.000176e1
* Trace resistance
Rtr_Gate_0_0 nGate_metal1 Gate 1.652778e-1
* Ground capacitance
Cgnd_Gate_0_0 Gate Bulk 1.289170e-16
* Trace resistance
Rtr_Source_1_0 Source nSource_metal1 1.785590e-1
* Ground capacitance
Cgnd_Source_1_0 nSource_metal1 Bulk 5.571055e-16
* Trace resistance
Rtr_Drain_2_0 nDrain_metal1 Drain 1.785590e-1
* Ground capacitance
Cgnd_Drain_2_0 Drain Bulk 5.571055e-16
* Trace resistance
Rtr_Bulk_3_0 nBulk_metal1 Bulk 8.263889e-2
* Ground capacitance
Cgnd_pour_Source_Metal nSource_metal1 Bulk 9.208355e-17
* Ground capacitance
Cgnd_pour_Drain_Metal nDrain_metal1 Bulk 9.208355e-17
* Ground capacitance
Cgnd_pour_Gate_Contact_LI nGate_li1 Bulk 2.762507e-17
* Ground capacitance
Cgnd_pour_Gate_Contact_Metal nGate_metal1 Bulk 3.683342e-17
* Ground capacitance
Cgnd_pour_Source_Pad Source Bulk 3.315008e-16
* Ground capacitance
Cgnd_pour_Drain_Pad Drain Bulk 3.315008e-16
* Ground capacitance
Cgnd_pour_Gate_Pad Gate Bulk 3.315008e-16

* Total parasitic elements: 22

.end
