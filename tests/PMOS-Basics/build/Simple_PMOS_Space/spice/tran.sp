* Hardware Script Transient Waveform Test
* Space: Simple_PMOS_Space
* Generated by hwc v0.2.1
* Format: SPICE3

.include "circuit.sp"

* ========================================
* STIMULUS & ANALYSIS
* ========================================
V_Source Source 0 DC 1.800
V_Bulk Bulk 0 DC 1.800
V_Gate Gate 0 PULSE(0.0 0.000 0.0 1.000e-12 1.000e-12 4.500e-9 1.000e-8)
V_Drain Drain 0 DC 0.000
.tran 1.000e-11 5.000e-8
.end
