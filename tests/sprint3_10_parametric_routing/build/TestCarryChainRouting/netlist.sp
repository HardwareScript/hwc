* Hardware Script Native Netlist: TestCarryChainRouting
* Generated by hwc v0.1.6 (Syntax Unification)
* Format: SPICE3

* ========================================
* NETS
* ========================================
* Net: Adder[0].carry_out_to_Adder[1].carry_in (width=100000nm, material=Copper)
* Net: Adder[1].carry_out_to_Adder[2].carry_in (width=100000nm, material=Copper)

* ========================================
* COMPONENTS
* ========================================
XAdder[0] nc_0 nc_1 nc_2 nc_3 Adder[0].carry_out_to_Adder[1].carry_in Adder
XAdder[1] nc_5 nc_6 Adder[0].carry_out_to_Adder[1].carry_in nc_8 Adder[1].carry_out_to_Adder[2].carry_in Adder
XAdder[2] nc_10 nc_11 Adder[1].carry_out_to_Adder[2].carry_in nc_13 Adder[2].carry_out_to_Adder[3].carry_in Adder
XAdder[3] nc_15 nc_16 Adder[2].carry_out_to_Adder[3].carry_in nc_18 nc_19 Adder

* ========================================
* DEVICE EXTRACTION REQUIRES EXPLICIT BINDINGS
* Use 'device: DeviceName.terminal' property
* ========================================

.end
