* Hardware Script Native Netlist: SimpleNMOS_Layout
* Generated by hwc v0.1.6 (Syntax Unification)
* Format: SPICE3

* ========================================
* NETS
* ========================================
* Net: VIN (pour: M1_Gate, material: Polysilicon, layer: 3)
* Net: GND (pour: M1_Source, material: Silicon_N, layer: 3)
* Net: VOUT (pour: M1_Drain, material: Silicon_N, layer: 3)
* Net: GND (pour: M1_Bulk, material: Silicon_P, layer: 3)
* Net: GND (pour: GND_Metal, material: Polysilicon, layer: 5)
* Net: VIN (width=100000nm, material=Polysilicon)
*   Connected pins:
*     - M1_Gate.anchor
* Net: GND (width=100000nm, material=Silicon_N)
*   Connected pins:
*     - M1_Source.anchor
*     - M1_Bulk.anchor
*     - GND_Metal.anchor
*     - Via_Source.via
*     - Via_Bulk.via
* Net: VOUT (width=100000nm, material=Silicon_N)
*   Connected pins:
*     - M1_Drain.anchor

* ========================================
* COMPONENTS
* ========================================
XM1_Gate VIN Pour(Polysilicon)
XM1_Source GND Pour(Silicon_N)
XM1_Drain VOUT Pour(Silicon_N)
XM1_Bulk GND Pour(Silicon_P)
XGND_Metal GND Pour(Polysilicon)
XVia_Source GND Contact(Polysilicon)
XVia_Bulk GND Contact(Polysilicon)

* ========================================
* EXTRACTED DEVICES (Transistors)
* ========================================
MM1 VOUT VIN GND GND NMOS W=0.10u L=0.10u AS=1.99e-8 AD=2.99e-8 PS=5.98e-4 PD=7.98e-4

.end
