* Hardware Script Native Netlist: TestAutoRouteObstacle
* Generated by hwc v0.1.6 (Syntax Unification)
* Format: SPICE3

* ========================================
* NETS
* ========================================
* Net: SIGNAL (pour: Pad1_Terminal, material: Copper, layer: 1)
* Net: SIGNAL (pour: Pad2_Terminal, material: Copper, layer: 1)
* Net: NET_A (pour: R1_TerminalA, material: Copper, layer: 1)
* Net: NET_K (pour: R1_TerminalK, material: Copper, layer: 1)
* Net: SIGNAL (width=100000nm, material=Copper)
* Net: NET_A (width=100000nm, material=Copper)

* ========================================
* COMPONENTS
* ========================================
XPad1 nc_0 PadWithNet
XPad1_Terminal SIGNAL Pour(Copper)
XPad2 nc_2 PadWithNet
XPad2_Terminal SIGNAL Pour(Copper)
XR1 nc_4 nc_5 BlockingResistor
XR1_TerminalA NET_A Pour(Copper)
XR1_TerminalK NET_K Pour(Copper)

* ========================================
* DEVICE EXTRACTION REQUIRES EXPLICIT BINDINGS
* Use 'device: DeviceName.terminal' property
* ========================================

.end
