* Hardware Script Native Netlist: TestRouteAroundComponent
* Generated by hwc v0.1.6 (Syntax Unification)
* Format: SPICE3

* ========================================
* COMPONENTS
* ========================================
XR1 nc_0 nc_1 Resistor
XR2 nc_2 nc_3 Resistor
XR3 nc_4 nc_5 Resistor

* ========================================
* DEVICE EXTRACTION REQUIRES EXPLICIT BINDINGS
* Use 'device: DeviceName.terminal' property
* ========================================

.end
