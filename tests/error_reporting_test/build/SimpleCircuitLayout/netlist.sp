* Hardware Script Native Netlist: SimpleCircuitLayout
* Generated by hwc v0.1.6 (Syntax Unification)
* Format: SPICE3

* ========================================
* NETS
* ========================================
* Net: VDD (pour: PAD1_Pad, material: Copper, layer: 2)

* ========================================
* COMPONENTS
* ========================================
XPAD1 VDD SimplePad
XPAD1_Pad VDD Pour(Copper)

* ========================================
* EXTRACTED DEVICES (Transistors)
* ========================================
MPAD1 0 0 0 0 SimplePad W=1.00u L=1.00u

.end
