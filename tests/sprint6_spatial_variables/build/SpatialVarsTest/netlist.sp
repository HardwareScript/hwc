* Hardware Script Native Netlist: SpatialVarsTest
* Generated by hwc v0.1.6 (Syntax Unification)
* Format: SPICE3

* ========================================
* COMPONENTS
* ========================================
XFloor1 nc_0 nc_1 Chip
XFloor2 nc_2 nc_3 Chip
XFloor3 nc_4 nc_5 Chip
XStack1 nc_6 nc_7 Chip

* ========================================
* DEVICE EXTRACTION REQUIRES EXPLICIT BINDINGS
* Use 'device: DeviceName.terminal' property
* ========================================

.end
