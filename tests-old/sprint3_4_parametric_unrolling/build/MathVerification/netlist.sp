* Hardware Script Native Netlist: MathVerification
* Generated by hwc v0.1.6 (Syntax Unification)
* Format: SPICE3

* ========================================
* NETS
* ========================================
* Net: Add[1] (pour: Test1_0, material: Copper, layer: 1)
* Net: Add[2] (pour: Test1_1, material: Copper, layer: 1)
* Net: Add[3] (pour: Test1_2, material: Copper, layer: 1)
* Net: Add[4] (pour: Test1_3, material: Copper, layer: 1)
* Net: Sub[10] (pour: Test2_0, material: Copper, layer: 1)
* Net: Sub[9] (pour: Test2_1, material: Copper, layer: 1)
* Net: Sub[8] (pour: Test2_2, material: Copper, layer: 1)
* Net: Sub[7] (pour: Test2_3, material: Copper, layer: 1)
* Net: Mul[0] (pour: Test3_0, material: Copper, layer: 1)
* Net: Mul[3] (pour: Test3_1, material: Copper, layer: 1)
* Net: Mul[6] (pour: Test3_2, material: Copper, layer: 1)
* Net: Mul[9] (pour: Test3_3, material: Copper, layer: 1)
* Net: Div[0] (pour: Test4_0, material: Copper, layer: 1)
* Net: Div[0] (pour: Test4_1, material: Copper, layer: 1)
* Net: Div[1] (pour: Test4_2, material: Copper, layer: 1)
* Net: Div[1] (pour: Test4_3, material: Copper, layer: 1)
* Net: Complex[7] (pour: Test5_0, material: Copper, layer: 1)
* Net: Complex[15] (pour: Test5_1, material: Copper, layer: 1)
* Net: Complex[23] (pour: Test5_2, material: Copper, layer: 1)
* Net: Complex[31] (pour: Test5_3, material: Copper, layer: 1)
* Net: Nested[2] (pour: Test6_0, material: Copper, layer: 1)
* Net: Nested[4] (pour: Test6_1, material: Copper, layer: 1)
* Net: Nested[6] (pour: Test6_2, material: Copper, layer: 1)
* Net: Nested[8] (pour: Test6_3, material: Copper, layer: 1)
* Net: Rev[7] (pour: Test7_0, material: Copper, layer: 1)
* Net: Rev[6] (pour: Test7_1, material: Copper, layer: 1)
* Net: Rev[5] (pour: Test7_2, material: Copper, layer: 1)
* Net: Rev[4] (pour: Test7_3, material: Copper, layer: 1)
* Net: Add[1] (width=100000nm, material=Copper)
* Net: Add[2] (width=100000nm, material=Copper)
* Net: Add[3] (width=100000nm, material=Copper)
* Net: Add[4] (width=100000nm, material=Copper)
* Net: Sub[10] (width=100000nm, material=Copper)
* Net: Sub[9] (width=100000nm, material=Copper)
* Net: Sub[8] (width=100000nm, material=Copper)
* Net: Sub[7] (width=100000nm, material=Copper)
* Net: Mul[0] (width=100000nm, material=Copper)
* Net: Mul[3] (width=100000nm, material=Copper)
* Net: Mul[6] (width=100000nm, material=Copper)
* Net: Mul[9] (width=100000nm, material=Copper)
* Net: Div[0] (width=100000nm, material=Copper)
* Net: Div[1] (width=100000nm, material=Copper)
* Net: Complex[7] (width=100000nm, material=Copper)
* Net: Complex[15] (width=100000nm, material=Copper)
* Net: Complex[23] (width=100000nm, material=Copper)
* Net: Complex[31] (width=100000nm, material=Copper)
* Net: Nested[2] (width=100000nm, material=Copper)
* Net: Nested[4] (width=100000nm, material=Copper)
* Net: Nested[6] (width=100000nm, material=Copper)
* Net: Nested[8] (width=100000nm, material=Copper)
* Net: Rev[7] (width=100000nm, material=Copper)
* Net: Rev[6] (width=100000nm, material=Copper)
* Net: Rev[5] (width=100000nm, material=Copper)

* ========================================
* COMPONENTS
* ========================================
XTest1_0 Add[1] Pour(Copper)
XTest1_1 Add[2] Pour(Copper)
XTest1_2 Add[3] Pour(Copper)
XTest1_3 Add[4] Pour(Copper)
XTest2_0 Sub[10] Pour(Copper)
XTest2_1 Sub[9] Pour(Copper)
XTest2_2 Sub[8] Pour(Copper)
XTest2_3 Sub[7] Pour(Copper)
XTest3_0 Mul[0] Pour(Copper)
XTest3_1 Mul[3] Pour(Copper)
XTest3_2 Mul[6] Pour(Copper)
XTest3_3 Mul[9] Pour(Copper)
XTest4_0 Div[0] Pour(Copper)
XTest4_1 Div[0] Pour(Copper)
XTest4_2 Div[1] Pour(Copper)
XTest4_3 Div[1] Pour(Copper)
XTest5_0 Complex[7] Pour(Copper)
XTest5_1 Complex[15] Pour(Copper)
XTest5_2 Complex[23] Pour(Copper)
XTest5_3 Complex[31] Pour(Copper)
XTest6_0 Nested[2] Pour(Copper)
XTest6_1 Nested[4] Pour(Copper)
XTest6_2 Nested[6] Pour(Copper)
XTest6_3 Nested[8] Pour(Copper)
XTest7_0 Rev[7] Pour(Copper)
XTest7_1 Rev[6] Pour(Copper)
XTest7_2 Rev[5] Pour(Copper)
XTest7_3 Rev[4] Pour(Copper)

* ========================================
* DEVICE EXTRACTION REQUIRES EXPLICIT BINDINGS
* Use 'device: DeviceName.terminal' property
* ========================================

.end
