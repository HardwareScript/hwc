* Hardware Script Native Netlist: TestNetIndexMath
* Generated by hwc v0.1.6 (Syntax Unification)
* Format: SPICE3

* ========================================
* NETS
* ========================================
* Net: D[1] (pour: Offset_0, material: Copper, layer: 1)
* Net: D[2] (pour: Offset_1, material: Copper, layer: 1)
* Net: D[3] (pour: Offset_2, material: Copper, layer: 1)
* Net: D[4] (pour: Offset_3, material: Copper, layer: 1)
* Net: Even[0] (pour: Even_0, material: Copper, layer: 1)
* Net: Even[2] (pour: Even_1, material: Copper, layer: 1)
* Net: Even[4] (pour: Even_2, material: Copper, layer: 1)
* Net: Even[6] (pour: Even_3, material: Copper, layer: 1)
* Net: Byte[7] (pour: MSB_0, material: Copper, layer: 1)
* Net: Byte[15] (pour: MSB_1, material: Copper, layer: 1)
* Net: Byte[23] (pour: MSB_2, material: Copper, layer: 1)
* Net: Byte[31] (pour: MSB_3, material: Copper, layer: 1)
* Net: Rev[7] (pour: Rev_0, material: Copper, layer: 1)
* Net: Rev[6] (pour: Rev_1, material: Copper, layer: 1)
* Net: Rev[5] (pour: Rev_2, material: Copper, layer: 1)
* Net: Rev[4] (pour: Rev_3, material: Copper, layer: 1)
* Net: D[1] (width=100000nm, material=Copper)
* Net: D[2] (width=100000nm, material=Copper)
* Net: D[3] (width=100000nm, material=Copper)
* Net: D[4] (width=100000nm, material=Copper)
* Net: Even[0] (width=100000nm, material=Copper)
* Net: Even[2] (width=100000nm, material=Copper)
* Net: Even[4] (width=100000nm, material=Copper)
* Net: Even[6] (width=100000nm, material=Copper)
* Net: Byte[7] (width=100000nm, material=Copper)
* Net: Byte[15] (width=100000nm, material=Copper)
* Net: Byte[23] (width=100000nm, material=Copper)
* Net: Byte[31] (width=100000nm, material=Copper)
* Net: Rev[7] (width=100000nm, material=Copper)
* Net: Rev[6] (width=100000nm, material=Copper)
* Net: Rev[5] (width=100000nm, material=Copper)

* ========================================
* COMPONENTS
* ========================================
XOffset_0 D[1] Pour(Copper)
XOffset_1 D[2] Pour(Copper)
XOffset_2 D[3] Pour(Copper)
XOffset_3 D[4] Pour(Copper)
XEven_0 Even[0] Pour(Copper)
XEven_1 Even[2] Pour(Copper)
XEven_2 Even[4] Pour(Copper)
XEven_3 Even[6] Pour(Copper)
XMSB_0 Byte[7] Pour(Copper)
XMSB_1 Byte[15] Pour(Copper)
XMSB_2 Byte[23] Pour(Copper)
XMSB_3 Byte[31] Pour(Copper)
XRev_0 Rev[7] Pour(Copper)
XRev_1 Rev[6] Pour(Copper)
XRev_2 Rev[5] Pour(Copper)
XRev_3 Rev[4] Pour(Copper)

* ========================================
* DEVICE EXTRACTION REQUIRES EXPLICIT BINDINGS
* Use 'device: DeviceName.terminal' property
* ========================================

.end
