* Hardware Script Native Netlist: IdentityCollisionTest
* Generated by hwc v0.1.6 (Syntax Unification)
* Format: SPICE3

* ========================================
* NETS
* ========================================
* Net: Collision[0] (pour: Test1_0, material: Copper, layer: 1)
* Net: Collision[0] (pour: Test1_1, material: Copper, layer: 1)
* Net: Collision[1] (pour: Test1_2, material: Copper, layer: 1)
* Net: Collision[1] (pour: Test1_3, material: Copper, layer: 1)
* Net: Div2[0] (pour: Test2_0, material: Copper, layer: 1)
* Net: Div2[0] (pour: Test2_1, material: Copper, layer: 1)
* Net: Div2[1] (pour: Test2_2, material: Copper, layer: 1)
* Net: Div2[1] (pour: Test2_3, material: Copper, layer: 1)
* Net: Div2[1] (pour: Test2_4, material: Copper, layer: 1)
* Net: Div2[2] (pour: Test2_5, material: Copper, layer: 1)
* Net: VDD (pour: VDD_Rail_0, material: Copper, layer: 1)
* Net: VDD (pour: VDD_Rail_1, material: Copper, layer: 1)
* Net: VDD (pour: VDD_Rail_2, material: Copper, layer: 1)
* Net: VDD (pour: VDD_Rail_3, material: Copper, layer: 1)
* Net: Collision[0] (width=100000nm, material=Copper)
* Net: Collision[0] (width=100000nm, material=Copper)
* Net: Collision[1] (width=100000nm, material=Copper)
* Net: Collision[1] (width=100000nm, material=Copper)
* Net: Div2[0] (width=100000nm, material=Copper)
* Net: Div2[0] (width=100000nm, material=Copper)
* Net: Div2[1] (width=100000nm, material=Copper)
* Net: Div2[1] (width=100000nm, material=Copper)
* Net: Div2[1] (width=100000nm, material=Copper)
* Net: Div2[2] (width=100000nm, material=Copper)

* ========================================
* COMPONENTS
* ========================================
XTest1_0 Collision[0] Pour(Copper)
XTest1_1 Collision[0] Pour(Copper)
XTest1_2 Collision[1] Pour(Copper)
XTest1_3 Collision[1] Pour(Copper)
XTest2_0 Div2[0] Pour(Copper)
XTest2_1 Div2[0] Pour(Copper)
XTest2_2 Div2[1] Pour(Copper)
XTest2_3 Div2[1] Pour(Copper)
XTest2_4 Div2[1] Pour(Copper)
XTest2_5 Div2[2] Pour(Copper)
XVDD_Rail_0 VDD Pour(Copper)
XVDD_Rail_1 VDD Pour(Copper)
XVDD_Rail_2 VDD Pour(Copper)
XVDD_Rail_3 VDD Pour(Copper)

* ========================================
* DEVICE EXTRACTION REQUIRES EXPLICIT BINDINGS
* Use 'device: DeviceName.terminal' property
* ========================================

.end
