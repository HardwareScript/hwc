* Hardware Script Native Netlist: Test64BitBusComprehensive
* Generated by hwc v0.1.6 (Syntax Unification)
* Format: SPICE3

* ========================================
* COMPONENTS
* ========================================
XAdder[0] nc_0 nc_1 nc_2 nc_3 nc_4 FullAdder
XAdder[1] nc_5 nc_6 nc_7 nc_8 nc_9 FullAdder
XAdder[2] nc_10 nc_11 nc_12 nc_13 nc_14 FullAdder
XAdder[3] nc_15 nc_16 nc_17 nc_18 nc_19 FullAdder
XAdder[4] nc_20 nc_21 nc_22 nc_23 nc_24 FullAdder
XAdder[5] nc_25 nc_26 nc_27 nc_28 nc_29 FullAdder
XAdder[6] nc_30 nc_31 nc_32 nc_33 nc_34 FullAdder
XAdder[7] nc_35 nc_36 nc_37 nc_38 nc_39 FullAdder
XAdder[8] nc_40 nc_41 nc_42 nc_43 nc_44 FullAdder
XAdder[9] nc_45 nc_46 nc_47 nc_48 nc_49 FullAdder
XAdder[10] nc_50 nc_51 nc_52 nc_53 nc_54 FullAdder
XAdder[11] nc_55 nc_56 nc_57 nc_58 nc_59 FullAdder
XAdder[12] nc_60 nc_61 nc_62 nc_63 nc_64 FullAdder
XAdder[13] nc_65 nc_66 nc_67 nc_68 nc_69 FullAdder
XAdder[14] nc_70 nc_71 nc_72 nc_73 nc_74 FullAdder
XAdder[15] nc_75 nc_76 nc_77 nc_78 nc_79 FullAdder
XAdder[16] nc_80 nc_81 nc_82 nc_83 nc_84 FullAdder
XAdder[17] nc_85 nc_86 nc_87 nc_88 nc_89 FullAdder
XAdder[18] nc_90 nc_91 nc_92 nc_93 nc_94 FullAdder
XAdder[19] nc_95 nc_96 nc_97 nc_98 nc_99 FullAdder
XAdder[20] nc_100 nc_101 nc_102 nc_103 nc_104 FullAdder
XAdder[21] nc_105 nc_106 nc_107 nc_108 nc_109 FullAdder
XAdder[22] nc_110 nc_111 nc_112 nc_113 nc_114 FullAdder
XAdder[23] nc_115 nc_116 nc_117 nc_118 nc_119 FullAdder
XAdder[24] nc_120 nc_121 nc_122 nc_123 nc_124 FullAdder
XAdder[25] nc_125 nc_126 nc_127 nc_128 nc_129 FullAdder
XAdder[26] nc_130 nc_131 nc_132 nc_133 nc_134 FullAdder
XAdder[27] nc_135 nc_136 nc_137 nc_138 nc_139 FullAdder
XAdder[28] nc_140 nc_141 nc_142 nc_143 nc_144 FullAdder
XAdder[29] nc_145 nc_146 nc_147 nc_148 nc_149 FullAdder
XAdder[30] nc_150 nc_151 nc_152 nc_153 nc_154 FullAdder
XAdder[31] nc_155 nc_156 nc_157 nc_158 nc_159 FullAdder
XAdder[32] nc_160 nc_161 nc_162 nc_163 nc_164 FullAdder
XAdder[33] nc_165 nc_166 nc_167 nc_168 nc_169 FullAdder
XAdder[34] nc_170 nc_171 nc_172 nc_173 nc_174 FullAdder
XAdder[35] nc_175 nc_176 nc_177 nc_178 nc_179 FullAdder
XAdder[36] nc_180 nc_181 nc_182 nc_183 nc_184 FullAdder
XAdder[37] nc_185 nc_186 nc_187 nc_188 nc_189 FullAdder
XAdder[38] nc_190 nc_191 nc_192 nc_193 nc_194 FullAdder
XAdder[39] nc_195 nc_196 nc_197 nc_198 nc_199 FullAdder
XAdder[40] nc_200 nc_201 nc_202 nc_203 nc_204 FullAdder
XAdder[41] nc_205 nc_206 nc_207 nc_208 nc_209 FullAdder
XAdder[42] nc_210 nc_211 nc_212 nc_213 nc_214 FullAdder
XAdder[43] nc_215 nc_216 nc_217 nc_218 nc_219 FullAdder
XAdder[44] nc_220 nc_221 nc_222 nc_223 nc_224 FullAdder
XAdder[45] nc_225 nc_226 nc_227 nc_228 nc_229 FullAdder
XAdder[46] nc_230 nc_231 nc_232 nc_233 nc_234 FullAdder
XAdder[47] nc_235 nc_236 nc_237 nc_238 nc_239 FullAdder
XAdder[48] nc_240 nc_241 nc_242 nc_243 nc_244 FullAdder
XAdder[49] nc_245 nc_246 nc_247 nc_248 nc_249 FullAdder
XAdder[50] nc_250 nc_251 nc_252 nc_253 nc_254 FullAdder
XAdder[51] nc_255 nc_256 nc_257 nc_258 nc_259 FullAdder
XAdder[52] nc_260 nc_261 nc_262 nc_263 nc_264 FullAdder
XAdder[53] nc_265 nc_266 nc_267 nc_268 nc_269 FullAdder
XAdder[54] nc_270 nc_271 nc_272 nc_273 nc_274 FullAdder
XAdder[55] nc_275 nc_276 nc_277 nc_278 nc_279 FullAdder
XAdder[56] nc_280 nc_281 nc_282 nc_283 nc_284 FullAdder
XAdder[57] nc_285 nc_286 nc_287 nc_288 nc_289 FullAdder
XAdder[58] nc_290 nc_291 nc_292 nc_293 nc_294 FullAdder
XAdder[59] nc_295 nc_296 nc_297 nc_298 nc_299 FullAdder
XAdder[60] nc_300 nc_301 nc_302 nc_303 nc_304 FullAdder
XAdder[61] nc_305 nc_306 nc_307 nc_308 nc_309 FullAdder
XAdder[62] nc_310 nc_311 nc_312 nc_313 nc_314 FullAdder
XAdder[63] nc_315 nc_316 nc_317 nc_318 nc_319 FullAdder

* ========================================
* DEVICE EXTRACTION REQUIRES EXPLICIT BINDINGS
* Use 'device: DeviceName.terminal' property
* ========================================

.end
