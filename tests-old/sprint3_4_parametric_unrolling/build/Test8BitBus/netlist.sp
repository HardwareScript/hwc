* Hardware Script Native Netlist: Test8BitBus
* Generated by hwc v0.1.6 (Syntax Unification)
* Format: SPICE3

* ========================================
* NETS
* ========================================
* Net: D[0] (pour: DataLine_0, material: Copper, layer: 1)
* Net: D[1] (pour: DataLine_1, material: Copper, layer: 1)
* Net: D[2] (pour: DataLine_2, material: Copper, layer: 1)
* Net: D[3] (pour: DataLine_3, material: Copper, layer: 1)
* Net: D[4] (pour: DataLine_4, material: Copper, layer: 1)
* Net: D[5] (pour: DataLine_5, material: Copper, layer: 1)
* Net: D[6] (pour: DataLine_6, material: Copper, layer: 1)
* Net: D[7] (pour: DataLine_7, material: Copper, layer: 1)
* Net: D[0] (width=100000nm, material=Copper)
* Net: D[1] (width=100000nm, material=Copper)
* Net: D[2] (width=100000nm, material=Copper)
* Net: D[3] (width=100000nm, material=Copper)
* Net: D[4] (width=100000nm, material=Copper)
* Net: D[5] (width=100000nm, material=Copper)
* Net: D[6] (width=100000nm, material=Copper)
* Net: D[7] (width=100000nm, material=Copper)
* Net: Bus[0] (width=100000nm, material=Copper)
* Net: Bus[1] (width=100000nm, material=Copper)
* Net: Bus[2] (width=100000nm, material=Copper)
* Net: Bus[3] (width=100000nm, material=Copper)
* Net: Bus[4] (width=100000nm, material=Copper)
* Net: Bus[5] (width=100000nm, material=Copper)
* Net: Bus[6] (width=100000nm, material=Copper)

* ========================================
* COMPONENTS
* ========================================
XDataLine_0 D[0] Pour(Copper)
XDataLine_1 D[1] Pour(Copper)
XDataLine_2 D[2] Pour(Copper)
XDataLine_3 D[3] Pour(Copper)
XDataLine_4 D[4] Pour(Copper)
XDataLine_5 D[5] Pour(Copper)
XDataLine_6 D[6] Pour(Copper)
XDataLine_7 D[7] Pour(Copper)
XVia_0 Bus[0] Contact(Copper)
XVia_1 Bus[1] Contact(Copper)
XVia_2 Bus[2] Contact(Copper)
XVia_3 Bus[3] Contact(Copper)
XVia_4 Bus[4] Contact(Copper)
XVia_5 Bus[5] Contact(Copper)
XVia_6 Bus[6] Contact(Copper)
XVia_7 Bus[7] Contact(Copper)

* ========================================
* DEVICE EXTRACTION REQUIRES EXPLICIT BINDINGS
* Use 'device: DeviceName.terminal' property
* ========================================

.end
