* Hardware Script Native Netlist: DivisionByZeroTest
* Generated by hwc v0.1.6 (Syntax Unification)
* Format: SPICE3

* ========================================
* NETS
* ========================================
* Net: Bus[10 / 0] (pour: Test_0, material: Copper, layer: 1)
* Net: Bus[10] (pour: Test_1, material: Copper, layer: 1)
* Net: Bus[5] (pour: Test_2, material: Copper, layer: 1)
* Net: Bus[3] (pour: Test_3, material: Copper, layer: 1)
* Net: Bus[10 / 0] (width=100000nm, material=Copper)
* Net: Bus[10] (width=100000nm, material=Copper)
* Net: Bus[5] (width=100000nm, material=Copper)

* ========================================
* COMPONENTS
* ========================================
XTest_0 Bus[10 / 0] Pour(Copper)
XTest_1 Bus[10] Pour(Copper)
XTest_2 Bus[5] Pour(Copper)
XTest_3 Bus[3] Pour(Copper)

* ========================================
* DEVICE EXTRACTION REQUIRES EXPLICIT BINDINGS
* Use 'device: DeviceName.terminal' property
* ========================================

.end
