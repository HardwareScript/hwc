* Hardware Script Native Netlist: Test8BitAdder
* Generated by hwc v0.1.6 (Syntax Unification)
* Format: SPICE3

* ========================================
* COMPONENTS
* ========================================
XAdder[0] nc_0 nc_1 nc_2 nc_3 nc_4 Adder
XAdder[1] nc_5 nc_6 nc_7 nc_8 nc_9 Adder
XAdder[2] nc_10 nc_11 nc_12 nc_13 nc_14 Adder
XAdder[3] nc_15 nc_16 nc_17 nc_18 nc_19 Adder
XAdder[4] nc_20 nc_21 nc_22 nc_23 nc_24 Adder
XAdder[5] nc_25 nc_26 nc_27 nc_28 nc_29 Adder
XAdder[6] nc_30 nc_31 nc_32 nc_33 nc_34 Adder
XAdder[7] nc_35 nc_36 nc_37 nc_38 nc_39 Adder

* ========================================
* DEVICE EXTRACTION REQUIRES EXPLICIT BINDINGS
* Use 'device: DeviceName.terminal' property
* ========================================

.end
