* Hardware Script Native Netlist: ZAxisAssemblySpace
* Generated by hwc v0.1.6 (Syntax Unification)
* Format: SPICE3

* ========================================
* NETS
* ========================================
* Net: VDD (pour: PhysicalMid, material: Copper, z: 0.0005mm)
* Net: VDD (pour: LowSlab, material: Copper, z: 0.0001mm)
* Net: VDD (pour: HighSlab, material: Copper, z: 0.0002mm)

* ========================================
* COMPONENTS
* ========================================
XPhysicalMid VDD Pour(Copper)
XLowSlab VDD Pour(Copper)
XHighSlab VDD Pour(Copper)
XAutoVia_VDD_1_6 VDD Contact(Copper)
XAutoVia_VDD_1_6 VDD Contact(Copper)
XAutoVia_VDD_1_6 VDD Contact(Copper)
XAutoVia_VDD_1_6 VDD Contact(Copper)
XAutoVia_VDD_1_6 VDD Contact(Copper)
XAutoVia_VDD_2_6 VDD Contact(Copper)
XAutoVia_VDD_2_6 VDD Contact(Copper)
XAutoVia_VDD_2_6 VDD Contact(Copper)
XAutoVia_VDD_2_6 VDD Contact(Copper)
XAutoVia_VDD_1_3 VDD Contact(Copper)
XAutoVia_VDD_1_3 VDD Contact(Copper)

.end
