* Hardware Script Native Netlist: ZAxisAssemblySpace
* Generated by hwc v0.1.6 (Syntax Unification)
* Format: SPICE3

* ========================================
* NETS
* ========================================
* Net: VDD (pour: PhysicalMid, material: TransCopper, z: 0.0005mm)
* Net: VDD (pour: LowSlab, material: TransSilver, z: 0.0001mm)
* Net: VDD (pour: HighSlab, material: TransGold, z: 0.0002mm)

* ========================================
* COMPONENTS
* ========================================
XPhysicalMid VDD Pour(TransCopper)
XLowSlab VDD Pour(TransSilver)
XHighSlab VDD Pour(TransGold)
XAutoVia_VDD_1_6 VDD Contact(TransCopper)
XAutoVia_VDD_1_6 VDD Contact(TransCopper)
XAutoVia_VDD_1_6 VDD Contact(TransCopper)
XAutoVia_VDD_1_6 VDD Contact(TransCopper)
XAutoVia_VDD_1_6 VDD Contact(TransCopper)
XAutoVia_VDD_2_6 VDD Contact(TransCopper)
XAutoVia_VDD_2_6 VDD Contact(TransCopper)
XAutoVia_VDD_2_6 VDD Contact(TransCopper)
XAutoVia_VDD_2_6 VDD Contact(TransCopper)
XAutoVia_VDD_1_3 VDD Contact(TransCopper)
XAutoVia_VDD_1_3 VDD Contact(TransCopper)

.end
