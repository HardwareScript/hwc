* Hardware Script Native Netlist: ThickDrillSpace
* Generated by hwc v0.1.6 (Syntax Unification)
* Format: SPICE3

* ========================================
* NETS
* ========================================
* Net: GND (pour: TopPad, material: DrilledCopper, z: 0.0016mm)
* Net: GND (pour: BottomPad, material: DrilledCopper, z: 0.0000mm)

* ========================================
* COMPONENTS
* ========================================
XTopPad GND Pour(DrilledCopper)
XBottomPad GND Pour(DrilledCopper)
XMasterDrill GND Contact(DrilledCopper)

.end
