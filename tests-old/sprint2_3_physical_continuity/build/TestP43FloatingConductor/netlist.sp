* Hardware Script Native Netlist: TestP43FloatingConductor
* Generated by hwc v0.1.6 (Syntax Unification)
* Format: SPICE3

* ========================================
* NETS
* ========================================
* Net: VCC (pour: FloatingPour, material: Copper, layer: 1)
* Net: GND (pour: FloatingGND, material: Copper, layer: 1)
* Net: VCC (width=100000nm, material=Copper)

* ========================================
* COMPONENTS
* ========================================
XFloatingPour VCC Pour(Copper)
XFloatingGND GND Pour(Copper)

.end
