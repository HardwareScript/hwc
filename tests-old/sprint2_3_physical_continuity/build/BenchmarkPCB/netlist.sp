* Hardware Script Native Netlist: BenchmarkPCB
* Generated by hwc v0.1.6 (Syntax Unification)
* Format: SPICE3

* ========================================
* NETS
* ========================================
* Net: VCC (pour: VCCPlane, material: Copper, layer: 2)
* Net: GND (pour: GNDPlane, material: Copper, layer: 2)
* Net: SIG1 (pour: Sig1_A, material: Copper, layer: 2)
* Net: SIG1 (pour: Sig1_B, material: Copper, layer: 2)
* Net: SIG2 (pour: Sig2_A, material: Copper, layer: 2)
* Net: SIG2 (pour: Sig2_B, material: Copper, layer: 2)
* Net: SIG3 (pour: Sig3_A, material: Copper, layer: 2)
* Net: SIG3 (pour: Sig3_B, material: Copper, layer: 2)
* Net: SIG4 (pour: Sig4_A, material: Copper, layer: 2)
* Net: SIG4 (pour: Sig4_B, material: Copper, layer: 2)
* Net: SIG5 (pour: Sig5_A, material: Copper, layer: 2)
* Net: SIG5 (pour: Sig5_B, material: Copper, layer: 2)
* Net: SIG6 (pour: Sig6_A, material: Copper, layer: 2)
* Net: SIG6 (pour: Sig6_B, material: Copper, layer: 2)
* Net: SIG7 (pour: Sig7_A, material: Copper, layer: 2)
* Net: SIG7 (pour: Sig7_B, material: Copper, layer: 2)
* Net: SIG8 (pour: Sig8_A, material: Copper, layer: 2)
* Net: SIG8 (pour: Sig8_B, material: Copper, layer: 2)
* Net: SIG9 (pour: Sig9_A, material: Copper, layer: 2)
* Net: SIG9 (pour: Sig9_B, material: Copper, layer: 2)
* Net: SIG10 (pour: Sig10_A, material: Copper, layer: 2)
* Net: SIG10 (pour: Sig10_B, material: Copper, layer: 2)
* Net: VCC (pour: TopVCC, material: Copper, layer: 4)
* Net: GND (pour: TopGND, material: Copper, layer: 4)
* Net: SIG1 (pour: TopSig1, material: Copper, layer: 4)
* Net: SIG2 (pour: TopSig2, material: Copper, layer: 4)
* Net: SIG3 (pour: TopSig3, material: Copper, layer: 4)
* Net: SIG4 (pour: TopSig4, material: Copper, layer: 4)
* Net: SIG5 (pour: TopSig5, material: Copper, layer: 4)
* Net: VCC (width=100000nm, material=Copper)
* Net: GND (width=100000nm, material=Copper)
*   Connected pins:
*     - TopVCC.anchor
*     - Via1.via
*     - Via2.via
*     - Via3.via
*     - Via4.via
*     - Via5.via
*     - Via6.via
*     - Via7.via
*     - Via8.via
*     - Via9.via
*     - Via10.via
* Net: SIG1 (width=100000nm, material=Copper)
*   Connected pins:
*     - TopGND.anchor
*     - Via11.via
*     - Via12.via
*     - Via13.via
*     - Via14.via
*     - Via15.via
*     - Via16.via
*     - Via17.via
*     - Via18.via
*     - Via19.via
*     - Via20.via
* Net: SIG2 (width=100000nm, material=Copper)
*   Connected pins:
*     - TopSig1.anchor
*     - Via21.via
*     - Via22.via
* Net: SIG3 (width=100000nm, material=Copper)
*   Connected pins:
*     - TopSig2.anchor
*     - Via23.via
*     - Via24.via
* Net: SIG4 (width=100000nm, material=Copper)
*   Connected pins:
*     - TopSig3.anchor
*     - Via25.via
*     - Via26.via
* Net: SIG5 (width=100000nm, material=Copper)
*   Connected pins:
*     - TopSig4.anchor
*     - Via27.via
*     - Via28.via
* Net: SIG6 (width=100000nm, material=Copper)
*   Connected pins:
*     - TopSig5.anchor
*     - Via29.via
*     - Via30.via
* Net: SIG7 (width=100000nm, material=Copper)
* Net: SIG8 (width=100000nm, material=Copper)
* Net: SIG9 (width=100000nm, material=Copper)

* ========================================
* COMPONENTS
* ========================================
XVCCPlane VCC Pour(Copper)
XGNDPlane GND Pour(Copper)
XSig1_A SIG1 Pour(Copper)
XSig1_B SIG1 Pour(Copper)
XSig2_A SIG2 Pour(Copper)
XSig2_B SIG2 Pour(Copper)
XSig3_A SIG3 Pour(Copper)
XSig3_B SIG3 Pour(Copper)
XSig4_A SIG4 Pour(Copper)
XSig4_B SIG4 Pour(Copper)
XSig5_A SIG5 Pour(Copper)
XSig5_B SIG5 Pour(Copper)
XSig6_A SIG6 Pour(Copper)
XSig6_B SIG6 Pour(Copper)
XSig7_A SIG7 Pour(Copper)
XSig7_B SIG7 Pour(Copper)
XSig8_A SIG8 Pour(Copper)
XSig8_B SIG8 Pour(Copper)
XSig9_A SIG9 Pour(Copper)
XSig9_B SIG9 Pour(Copper)
XSig10_A SIG10 Pour(Copper)
XSig10_B SIG10 Pour(Copper)
XTopVCC VCC Pour(Copper)
XTopGND GND Pour(Copper)
XTopSig1 SIG1 Pour(Copper)
XTopSig2 SIG2 Pour(Copper)
XTopSig3 SIG3 Pour(Copper)
XTopSig4 SIG4 Pour(Copper)
XTopSig5 SIG5 Pour(Copper)
XVia1 VCC Contact(Copper)
XVia2 VCC Contact(Copper)
XVia3 VCC Contact(Copper)
XVia4 VCC Contact(Copper)
XVia5 VCC Contact(Copper)
XVia6 VCC Contact(Copper)
XVia7 VCC Contact(Copper)
XVia8 VCC Contact(Copper)
XVia9 VCC Contact(Copper)
XVia10 VCC Contact(Copper)
XVia11 GND Contact(Copper)
XVia12 GND Contact(Copper)
XVia13 GND Contact(Copper)
XVia14 GND Contact(Copper)
XVia15 GND Contact(Copper)
XVia16 GND Contact(Copper)
XVia17 GND Contact(Copper)
XVia18 GND Contact(Copper)
XVia19 GND Contact(Copper)
XVia20 GND Contact(Copper)
XVia21 SIG1 Contact(Copper)
XVia22 SIG1 Contact(Copper)
XVia23 SIG2 Contact(Copper)
XVia24 SIG2 Contact(Copper)
XVia25 SIG3 Contact(Copper)
XVia26 SIG3 Contact(Copper)
XVia27 SIG4 Contact(Copper)
XVia28 SIG4 Contact(Copper)
XVia29 SIG5 Contact(Copper)
XVia30 SIG5 Contact(Copper)

* ========================================
* DEVICE EXTRACTION REQUIRES EXPLICIT BINDINGS
* Use 'device: DeviceName.terminal' property
* ========================================

.end
