* Hardware Script Native Netlist: TestViaBridge
* Generated by hwc v0.1.6 (Syntax Unification)
* Format: SPICE3

* ========================================
* NETS
* ========================================
* Net: VCC (pour: VCC_Bottom, material: Copper, layer: 1)
* Net: VCC (pour: VCC_Top, material: Copper, layer: 5)
* Net: GND (pour: GND_Plane, material: Copper, layer: 3)
* Net: VCC (width=100000nm, material=Copper)

* ========================================
* COMPONENTS
* ========================================
XVCC_Bottom VCC Pour(Copper)
XVCC_Top VCC Pour(Copper)
XGND_Plane GND Pour(Copper)
XVCC_Via VCC Contact(Copper)

.end
