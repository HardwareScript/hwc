* Hardware Script Native Netlist: PTH_Gallery
* Generated by hwc v0.1.6 (Syntax Unification)
* Format: SPICE3

* ========================================
* DEVICE EXTRACTION REQUIRES EXPLICIT BINDINGS
* Use 'device: DeviceName.terminal' property
* ========================================

.end
