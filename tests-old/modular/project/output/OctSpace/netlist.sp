* Hardware Script Native Netlist: OctSpace
* Generated by hwc v0.1.6 (Syntax Unification)
* Format: SPICE3

* ========================================
* NETS
* ========================================

* ========================================
* COMPONENTS
* ========================================
XP3 NET_P3_p_to_P4_p Pad
XP4 NET_P3_p_to_P4_p Pad
XAutoVia_NET_P3_p_to_P4_p_0_2 NET_P3_p_to_P4_p Contact(Copper)
XAutoVia_NET_P3_p_to_P4_p_2_4 NET_P3_p_to_P4_p Contact(Copper)

* ========================================
* DEVICE EXTRACTION REQUIRES EXPLICIT BINDINGS
* Use 'device: DeviceName.terminal' property
* ========================================

.end
