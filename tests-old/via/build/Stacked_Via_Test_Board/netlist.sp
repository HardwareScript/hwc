* Hardware Script Native Netlist: Stacked_Via_Test_Board
* Generated by hwc v0.1.6 (Syntax Unification)
* Format: SPICE3

* ========================================
* NETS
* ========================================

* ========================================
* COMPONENTS
* ========================================
XTop_Microvia SIG Contact(ViaCopper)
XBuried_Via SIG Contact(ViaCopper)
XBottom_Microvia SIG Contact(ViaCopper)

.end
