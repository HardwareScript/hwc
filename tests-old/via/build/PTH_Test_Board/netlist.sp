* Hardware Script Native Netlist: PTH_Test_Board
* Generated by hwc v0.1.6 (Syntax Unification)
* Format: SPICE3

* ========================================
* NETS
* ========================================

* ========================================
* COMPONENTS
* ========================================
XPTH_Via SIG Contact(ViaCopper)

.end
