* Hardware Script Native Netlist: ViaTestBoard
* Generated by hwc v0.1.6 (Syntax Unification)
* Format: SPICE3

* ========================================
* NETS
* ========================================
* Net: P1 (pour: TopPlane, material: Copper, z: 1.5000mm)
* Net: P1 (pour: BottomPlane, material: Copper, z: 0.0000mm)

* ========================================
* COMPONENTS
* ========================================
XV1 P1 Contact(Copper)
XV2 P1 Contact(Copper)
XTopPlane P1 Pour(Copper)
XBottomPlane P1 Pour(Copper)

.end
