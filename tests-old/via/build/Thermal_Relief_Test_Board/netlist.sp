* Hardware Script Native Netlist: Thermal_Relief_Test_Board
* Generated by hwc v0.1.6 (Syntax Unification)
* Format: SPICE3

* ========================================
* NETS
* ========================================
* Net: SIG (pour: InnerGndPlane, material: ViaCopper, z: 1.0950mm)

* ========================================
* COMPONENTS
* ========================================
XInnerGndPlane SIG Pour(ViaCopper)
XThermal_Via SIG Contact(ViaCopper)

.end
