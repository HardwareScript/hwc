* Hardware Script Native Netlist: NFP_Test_Board
* Generated by hwc v0.1.6 (Syntax Unification)
* Format: SPICE3

* ========================================
* NETS
* ========================================
* Net: GND (pour: Inner1_GND, material: ViaCopper, z: 1.3300mm)
* Net: SIG (pour: Inner2_SIG, material: ViaCopper, z: 0.2350mm)
* Net: GND (width=100000nm, material=ViaCopper)

* ========================================
* COMPONENTS
* ========================================
XInner1_GND GND Pour(ViaCopper)
XInner2_SIG SIG Pour(ViaCopper)
XNFP_Via SIG Contact(ViaCopper)

.end
