* Hardware Script Native Netlist: VIPPO_Test_Board
* Generated by hwc v0.1.6 (Syntax Unification)
* Format: SPICE3

* ========================================
* NETS
* ========================================

* ========================================
* COMPONENTS
* ========================================
XVIPPO_Via SIG Contact(ViaCopper)

.end
