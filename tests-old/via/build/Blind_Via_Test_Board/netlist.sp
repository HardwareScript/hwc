* Hardware Script Native Netlist: Blind_Via_Test_Board
* Generated by hwc v0.1.6 (Syntax Unification)
* Format: SPICE3

* ========================================
* NETS
* ========================================

* ========================================
* COMPONENTS
* ========================================
XBlind_Via SIG Contact(ViaCopper)

.end
