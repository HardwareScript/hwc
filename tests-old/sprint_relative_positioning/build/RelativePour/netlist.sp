* Hardware Script Native Netlist: RelativePour
* Generated by hwc v0.1.6 (Syntax Unification)
* Format: SPICE3

* ========================================
* NETS
* ========================================
* Net: VDD (pour: P1, material: Copper, layer: 1)
* Net: VDD (pour: PR[0], material: Copper, layer: 1)
* Net: VDD (pour: PR[1], material: Copper, layer: 1)
* Net: VDD (pour: PR[2], material: Copper, layer: 1)

* ========================================
* COMPONENTS
* ========================================
XL1 VDD VDD LED
XP1 VDD Pour(Copper)
XR[0] VDD VDD Resistor
XR[1] VDD VDD Resistor
XR[2] VDD VDD Resistor
XPR[0] VDD Pour(Copper)
XPR[1] VDD Pour(Copper)
XPR[2] VDD Pour(Copper)

.end
