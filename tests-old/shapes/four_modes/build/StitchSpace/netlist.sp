* Hardware Script Native Netlist: StitchSpace
* Generated by hwc v0.1.6 (Syntax Unification)
* Format: SPICE3

* ========================================
* NETS
* ========================================

* ========================================
* COMPONENTS
* ========================================
XStart NET_Start_p_to_End_p Pad
XEnd NET_Start_p_to_End_p Pad
XAutoVia_NET_Start_p_to_End_p_0_2 NET_Start_p_to_End_p Contact(Copper)

* ========================================
* DEVICE EXTRACTION REQUIRES EXPLICIT BINDINGS
* Use 'device: DeviceName.terminal' property
* ========================================

.end
