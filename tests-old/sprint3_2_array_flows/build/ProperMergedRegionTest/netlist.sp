* Hardware Script Native Netlist: ProperMergedRegionTest
* Generated by hwc v0.1.6 (Syntax Unification)
* Format: SPICE3

* ========================================
* NETS
* ========================================
* Net: VDD (merged region: M_Array[0-2].drain, 1 instances, total area: 20000000 nm², material: Silicon_N, layer: 1)
*   Parasitic extraction: Treat as single electrical node
* Net: GND (merged region: M_Array[0-2].source, 1 instances, total area: 20000000 nm², material: Silicon_N, layer: 1)
*   Parasitic extraction: Treat as single electrical node
* Net: GND (pour: M_Array[0]_source, material: Silicon_N, layer: 1)
* Net: VDD (pour: M_Array[0]_drain, material: Silicon_N, layer: 1)
* Net: GND (pour: M_Array[1]_source, material: Silicon_N, layer: 1)
* Net: VDD (pour: M_Array[1]_drain, material: Silicon_N, layer: 1)
* Net: GND (pour: M_Array[2]_source, material: Silicon_N, layer: 1)
* Net: VDD (pour: M_Array[2]_drain, material: Silicon_N, layer: 1)
* Net: GND (width=100000nm, material=Silicon_N)

* ========================================
* COMPONENTS
* ========================================
XM_Array[0] nc_0 nc_1 nc_2 TransistorFinger
XM_Array[0]_source GND Pour(Silicon_N)
XM_Array[0]_drain VDD Pour(Silicon_N)
XM_Array[1] nc_5 nc_6 nc_7 TransistorFinger
XM_Array[1]_source GND Pour(Silicon_N)
XM_Array[1]_drain VDD Pour(Silicon_N)
XM_Array[2] nc_10 nc_11 nc_12 TransistorFinger
XM_Array[2]_source GND Pour(Silicon_N)
XM_Array[2]_drain VDD Pour(Silicon_N)

* ========================================
* DEVICE EXTRACTION REQUIRES EXPLICIT BINDINGS
* Use 'device: DeviceName.terminal' property
* ========================================

.end
