* Hardware Script Native Netlist: NoCollisionTest
* Generated by hwc v0.1.6 (Syntax Unification)
* Format: SPICE3

* ========================================
* NETS
* ========================================
* Net: GND (pour: Safe_Array[0]_source, material: Silicon_N, layer: 1)
* Net: VDD (pour: Safe_Array[0]_drain, material: Silicon_N, layer: 1)
* Net: GND (pour: Safe_Array[1]_source, material: Silicon_N, layer: 1)
* Net: VDD (pour: Safe_Array[1]_drain, material: Silicon_N, layer: 1)
* Net: GND (pour: Safe_Array[2]_source, material: Silicon_N, layer: 1)
* Net: VDD (pour: Safe_Array[2]_drain, material: Silicon_N, layer: 1)
* Net: GND (pour: Safe_Array[3]_source, material: Silicon_N, layer: 1)
* Net: VDD (pour: Safe_Array[3]_drain, material: Silicon_N, layer: 1)
* Net: GND (pour: Safe_Array[4]_source, material: Silicon_N, layer: 1)
* Net: VDD (pour: Safe_Array[4]_drain, material: Silicon_N, layer: 1)
* Net: GND (pour: Safe_Vertical[0]_source, material: Silicon_N, layer: 1)
* Net: VDD (pour: Safe_Vertical[0]_drain, material: Silicon_N, layer: 1)
* Net: GND (pour: Safe_Vertical[1]_source, material: Silicon_N, layer: 1)
* Net: VDD (pour: Safe_Vertical[1]_drain, material: Silicon_N, layer: 1)
* Net: GND (pour: Safe_Vertical[2]_source, material: Silicon_N, layer: 1)
* Net: VDD (pour: Safe_Vertical[2]_drain, material: Silicon_N, layer: 1)
* Net: GND (width=100000nm, material=Silicon_N)

* ========================================
* COMPONENTS
* ========================================
XSafe_Array[0] nc_0 nc_1 SafeFinger
XSafe_Array[0]_source GND Pour(Silicon_N)
XSafe_Array[0]_drain VDD Pour(Silicon_N)
XSafe_Array[1] nc_4 nc_5 SafeFinger
XSafe_Array[1]_source GND Pour(Silicon_N)
XSafe_Array[1]_drain VDD Pour(Silicon_N)
XSafe_Array[2] nc_8 nc_9 SafeFinger
XSafe_Array[2]_source GND Pour(Silicon_N)
XSafe_Array[2]_drain VDD Pour(Silicon_N)
XSafe_Array[3] nc_12 nc_13 SafeFinger
XSafe_Array[3]_source GND Pour(Silicon_N)
XSafe_Array[3]_drain VDD Pour(Silicon_N)
XSafe_Array[4] nc_16 nc_17 SafeFinger
XSafe_Array[4]_source GND Pour(Silicon_N)
XSafe_Array[4]_drain VDD Pour(Silicon_N)
XSafe_Vertical[0] nc_20 nc_21 SafeFinger
XSafe_Vertical[0]_source GND Pour(Silicon_N)
XSafe_Vertical[0]_drain VDD Pour(Silicon_N)
XSafe_Vertical[1] nc_24 nc_25 SafeFinger
XSafe_Vertical[1]_source GND Pour(Silicon_N)
XSafe_Vertical[1]_drain VDD Pour(Silicon_N)
XSafe_Vertical[2] nc_28 nc_29 SafeFinger
XSafe_Vertical[2]_source GND Pour(Silicon_N)
XSafe_Vertical[2]_drain VDD Pour(Silicon_N)

* ========================================
* DEVICE EXTRACTION REQUIRES EXPLICIT BINDINGS
* Use 'device: DeviceName.terminal' property
* ========================================

.end
