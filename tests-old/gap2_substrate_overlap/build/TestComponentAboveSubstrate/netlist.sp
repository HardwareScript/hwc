* Hardware Script Native Netlist: TestComponentAboveSubstrate
* Generated by hwc v0.1.6 (Syntax Unification)
* Format: SPICE3

* ========================================
* COMPONENTS
* ========================================
XLED1 nc_0 nc_1 LED

* ========================================
* DEVICE EXTRACTION REQUIRES EXPLICIT BINDINGS
* Use 'device: DeviceName.terminal' property
* ========================================

.end
