* Hardware Script Native Netlist: SimpleConnection
* Generated by hwc v0.1.6 (Syntax Unification)
* Format: SPICE3

* ========================================
* NETS
* ========================================
* Net: POWER_BUS (pour: Plate1, material: Copper, z: 0.0015mm)
* Net: POWER_BUS (pour: Plate2, material: Copper, z: 0.0015mm)

* ========================================
* COMPONENTS
* ========================================
XPlate1 POWER_BUS Pour(Copper)
XPlate2 POWER_BUS Pour(Copper)

* ========================================
* DEVICE EXTRACTION REQUIRES EXPLICIT BINDINGS
* Use 'device: DeviceName.terminal' property
* ========================================

.end
