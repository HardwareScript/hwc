* Hardware Script Native Netlist: RoutingTestBoard
* Generated by hwc v0.1.6 (Syntax Unification)
* Format: SPICE3

* ========================================
* NETS
* ========================================
* Net: NET_VIAS (width=100000nm, material=Copper)
* Net: NET_VIA_PAD (width=100000nm, material=Copper)
* Net: NET_Pad_A_P_to_Pad_B_P (width=100000nm, material=Copper)
* Net: NET_Via_A_Anchor_P_to_Via_B_Anchor_P (width=100000nm, material=Copper)

* ========================================
* COMPONENTS
* ========================================
XPad_A NET_Pad_A_P_to_Pad_B_P RoundPin
XPad_B NET_Pad_A_P_to_Pad_B_P RoundPin
XVia_A NET_VIAS Contact(Copper)
XVia_A_Anchor NET_Via_A_Anchor_P_to_Via_B_Anchor_P Pin
XVia_B NET_VIAS Contact(Copper)
XVia_B_Anchor NET_Via_A_Anchor_P_to_Via_B_Anchor_P Pin
XVia_C NET_VIA_PAD Contact(Copper)
XVia_C_Anchor NET_Via_C_Anchor_P_to_Pad_C_P Pin
XPad_C NET_Via_C_Anchor_P_to_Pad_C_P RoundPin

* ========================================
* DEVICE EXTRACTION REQUIRES EXPLICIT BINDINGS
* Use 'device: DeviceName.terminal' property
* ========================================

.end
