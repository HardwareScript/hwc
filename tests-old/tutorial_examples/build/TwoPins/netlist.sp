* Hardware Script Native Netlist: TwoPins
* Generated by hwc v0.1.6 (Syntax Unification)
* Format: SPICE3

* ========================================
* NETS
* ========================================

* ========================================
* COMPONENTS
* ========================================
XA NET_A_P_to_B_P Pin
XB NET_A_P_to_B_P Pin

* ========================================
* DEVICE EXTRACTION REQUIRES EXPLICIT BINDINGS
* Use 'device: DeviceName.terminal' property
* ========================================

.end
