* Hardware Script Native Netlist: EscapeRouteBoard
* Generated by hwc v0.1.6 (Syntax Unification)
* Format: SPICE3

* ========================================
* NETS
* ========================================
* Net: NET_Center_N_to_North_P (pour: Center_Pad, material: Copper, z: 1.5350mm)
* Net: NET_Center_N_to_North_P (pour: North_Pad, material: Copper, z: 1.5350mm)
* Net: NET_Center_S_to_South_P (pour: South_Pad, material: Copper, z: 1.5350mm)
* Net: NET_Center_E_to_East_P (pour: East_Pad, material: Copper, z: 1.5350mm)
* Net: NET_Center_W_to_West_P (pour: West_Pad, material: Copper, z: 1.5350mm)
* Net: NET_Center_N_to_North_P (width=100000nm, material=Copper)
* Net: NET_Center_S_to_South_P (width=100000nm, material=Copper)
* Net: NET_Center_E_to_East_P (width=100000nm, material=Copper)

* ========================================
* COMPONENTS
* ========================================
XCenter NET_Center_N_to_North_P NET_Center_S_to_South_P NET_Center_E_to_East_P NET_Center_W_to_West_P CenterPad
XNorth NET_Center_N_to_North_P NorthPad
XSouth NET_Center_S_to_South_P SouthPad
XEast NET_Center_E_to_East_P EastPad
XWest NET_Center_W_to_West_P WestPad

* ========================================
* DEVICE EXTRACTION REQUIRES EXPLICIT BINDINGS
* Use 'device: DeviceName.terminal' property
* ========================================

.end
