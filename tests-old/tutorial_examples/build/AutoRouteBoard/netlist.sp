* Hardware Script Native Netlist: AutoRouteBoard
* Generated by hwc v0.1.6 (Syntax Unification)
* Format: SPICE3

* ========================================
* NETS
* ========================================
* Net: NET_West_P_to_East_P (pour: West_Pad, material: Copper, z: 1.5350mm)
* Net: NET_West_P_to_East_P (pour: East_Pad, material: Copper, z: 1.5350mm)

* ========================================
* COMPONENTS
* ========================================
XWest NET_West_P_to_East_P Pad
XEast NET_West_P_to_East_P Pad

* ========================================
* DEVICE EXTRACTION REQUIRES EXPLICIT BINDINGS
* Use 'device: DeviceName.terminal' property
* ========================================

.end
