* Hardware Script Native Netlist: RingEscapeBoard
* Generated by hwc v0.1.6 (Syntax Unification)
* Format: SPICE3

* ========================================
* NETS
* ========================================
* Net: NET_Wing_N_to_RingN_P (pour: Wing_Wing, material: Copper, z: 1.5350mm)
* Net: NET_Wing_N_to_RingN_P (pour: RingN_Ring, material: Copper, z: 1.5350mm)
* Net: NET_Wing_S_to_RingS_P (pour: RingS_Ring, material: Copper, z: 1.5350mm)
* Net: NET_Wing_E_to_RingE_P (pour: RingE_Ring, material: Copper, z: 1.5350mm)
* Net: NET_Wing_W_to_RingW_P (pour: RingW_Ring, material: Copper, z: 1.5350mm)
* Net: NET_Wing_N_to_RingN_P (width=100000nm, material=Copper)
* Net: NET_Wing_S_to_RingS_P (width=100000nm, material=Copper)
* Net: NET_Wing_E_to_RingE_P (width=100000nm, material=Copper)

* ========================================
* COMPONENTS
* ========================================
XWing NET_Wing_N_to_RingN_P NET_Wing_S_to_RingS_P NET_Wing_E_to_RingE_P NET_Wing_W_to_RingW_P MidWing
XRingN NET_Wing_N_to_RingN_P RingPad
XRingS NET_Wing_S_to_RingS_P RingPad
XRingE NET_Wing_E_to_RingE_P RingPad
XRingW NET_Wing_W_to_RingW_P RingPad

* ========================================
* DEVICE EXTRACTION REQUIRES EXPLICIT BINDINGS
* Use 'device: DeviceName.terminal' property
* ========================================

.end
