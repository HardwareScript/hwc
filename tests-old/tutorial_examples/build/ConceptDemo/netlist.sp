* Hardware Script Native Netlist: ConceptDemo
* Generated by hwc v0.1.6 (Syntax Unification)
* Format: SPICE3

* ========================================
* NETS
* ========================================

* ========================================
* COMPONENTS
* ========================================
XPad_A NET_Pad_A_P_to_Pad_B_P CenterPad
XPad_B NET_Pad_A_P_to_Pad_B_P CenterPad

* ========================================
* DEVICE EXTRACTION REQUIRES EXPLICIT BINDINGS
* Use 'device: DeviceName.terminal' property
* ========================================

.end
