* Hardware Script Native Netlist: BigBoardSpace
* Generated by hwc v0.1.6 (Syntax Unification)
* Format: SPICE3

* ========================================
* NETS
* ========================================
* Net: MAIN_BUS (pour: Plate1, material: Copper_Gold, z: 0.0015mm)
* Net: MAIN_BUS (pour: Plate2, material: Copper_Gold, z: 0.0015mm)

* ========================================
* COMPONENTS
* ========================================
XPlate1 MAIN_BUS Pour(Copper_Gold)
XPlate2 MAIN_BUS Pour(Copper_Gold)

* ========================================
* DEVICE EXTRACTION REQUIRES EXPLICIT BINDINGS
* Use 'device: DeviceName.terminal' property
* ========================================

.end
