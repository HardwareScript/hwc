* Hardware Script Native Netlist: RingToRingBoard
* Generated by hwc v0.1.6 (Syntax Unification)
* Format: SPICE3

* ========================================
* NETS
* ========================================
* Net: NET_Ring_A_P_to_Ring_B_P (pour: Ring_A_Ring, material: Copper, z: 1.5350mm)
* Net: NET_Ring_A_P_to_Ring_B_P (pour: Ring_B_Ring, material: Copper, z: 1.5350mm)

* ========================================
* COMPONENTS
* ========================================
XRing_A NET_Ring_A_P_to_Ring_B_P RingPad
XRing_B NET_Ring_A_P_to_Ring_B_P RingPad

* ========================================
* DEVICE EXTRACTION REQUIRES EXPLICIT BINDINGS
* Use 'device: DeviceName.terminal' property
* ========================================

.end
