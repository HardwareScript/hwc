* Hardware Script Native Netlist: TestComponentWithInternalPours
* Generated by hwc v0.1.6 (Syntax Unification)
* Format: SPICE3

* ========================================
* NETS
* ========================================
* Net: GND (pour: M1_Bulk, material: Silicon_P, layer: 1)
* Net: GND (pour: M1_Source, material: Silicon_N, layer: 2)
* Net: VOUT (pour: M1_Drain, material: Silicon_N, layer: 2)
* Net: VIN (pour: M1_Gate, material: Polysilicon, layer: 4)
* Net: GND (width=100000nm, material=Silicon_P)
* Net: VOUT (width=100000nm, material=Silicon_N)

* ========================================
* COMPONENTS
* ========================================
XM1 nc_0 nc_1 nc_2 nc_3 SimpleNMOS
XM1_Bulk GND Pour(Silicon_P)
XM1_Source GND Pour(Silicon_N)
XM1_Drain VOUT Pour(Silicon_N)
XM1_Gate VIN Pour(Polysilicon)

* ========================================
* EXTRACTED DEVICES (Transistors)
* ========================================
MM1 VOUT VIN GND GND SimpleNMOS W=0.10u L=0.10u AS=2.00e-8 AD=2.00e-8 PS=6.00e-4 PD=6.00e-4

.end
