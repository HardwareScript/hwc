* Hardware Script Native Netlist: ComponentStampingTest
* Generated by hwc v0.1.6 (Syntax Unification)
* Format: SPICE3

* ========================================
* COMPONENTS
* ========================================
XR1 nc_0 nc_1 SimpleResistor
XR2 nc_2 nc_3 SimpleResistor
XR3 nc_4 nc_5 SimpleResistor
XR4 nc_6 nc_7 SimpleResistor

* ========================================
* DEVICE EXTRACTION REQUIRES EXPLICIT BINDINGS
* Use 'device: DeviceName.terminal' property
* ========================================

.end
