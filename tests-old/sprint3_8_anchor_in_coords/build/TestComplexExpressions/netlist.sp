* Hardware Script Native Netlist: TestComplexExpressions
* Generated by hwc v0.1.6 (Syntax Unification)
* Format: SPICE3

* ========================================
* NETS
* ========================================
* Net: GND (pour: BasePlane, material: Copper, layer: 1)
* Net: VDD (pour: ComplexPour, material: Copper, layer: 1)
* Net: GND (width=100000nm, material=Copper)

* ========================================
* COMPONENTS
* ========================================
XBasePlane GND Pour(Copper)
XBlock1 nc_1 nc_2 SmallBlock
XArray[0] nc_3 nc_4 SmallBlock
XArray[1] nc_5 nc_6 SmallBlock
XArray[2] nc_7 nc_8 SmallBlock
XArray[3] nc_9 nc_10 SmallBlock
XFinalBlock nc_11 nc_12 SmallBlock
XComplexPour VDD Pour(Copper)

* ========================================
* DEVICE EXTRACTION REQUIRES EXPLICIT BINDINGS
* Use 'device: DeviceName.terminal' property
* ========================================

.end
