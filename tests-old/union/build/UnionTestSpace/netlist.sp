* Hardware Script Native Netlist: UnionTestSpace
* Generated by hwc v0.1.6 (Syntax Unification)
* Format: SPICE3

* ========================================
* NETS
* ========================================
* Net: UnionNet (pour: RectA, material: Copper, z: 1.5000mm)
* Net: UnionNet (pour: RectB, material: Copper, z: 1.5000mm)
* Net: UnionNet (pour: ConnectingTrace, material: Copper, z: 1.5000mm)
* Net: UnionNet (pour: Bridge, material: Copper, z: 1.5000mm)
* Net: IsolationNet (pour: IsolatedRect, material: Copper, z: 1.5000mm)
* Net: UnionNet (width=100000nm, material=Copper)

* ========================================
* COMPONENTS
* ========================================
XRectA UnionNet Pour(Copper)
XRectB UnionNet Pour(Copper)
XConnectingTrace UnionNet Pour(Copper)
XBridge UnionNet Pour(Copper)
XPadC UnionNet Contact(Copper)
XIsolatedRect IsolationNet Pour(Copper)

.end
