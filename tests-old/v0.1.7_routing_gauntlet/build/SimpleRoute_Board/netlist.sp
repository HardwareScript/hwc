* Hardware Script Native Netlist: SimpleRoute_Board
* Generated by hwc v0.1.6 (Syntax Unification)
* Format: SPICE3

* ========================================
* NETS
* ========================================
* Net: NET_A_P_to_B_P (pour: Pad_A, material: ViaCopper, z: 1.5350mm)
* Net: NET_A_P_to_B_P (pour: Pad_B, material: ViaCopper, z: 1.5350mm)
* Net: NET_A_P_to_B_P (width=100000nm, material=ViaCopper)

* ========================================
* COMPONENTS
* ========================================
XPad_A NET_A_P_to_B_P Pour(ViaCopper)
XA NET_A_P_to_B_P Pin
XPad_B NET_A_P_to_B_P Pour(ViaCopper)
XB NET_A_P_to_B_P Pin

* ========================================
* DEVICE EXTRACTION REQUIRES EXPLICIT BINDINGS
* Use 'device: DeviceName.terminal' property
* ========================================

.end
