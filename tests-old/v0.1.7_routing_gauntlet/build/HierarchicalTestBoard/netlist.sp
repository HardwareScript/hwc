* Hardware Script Native Netlist: HierarchicalTestBoard
* Generated by hwc v0.1.6 (Syntax Unification)
* Format: SPICE3

* ========================================
* NETS
* ========================================
* Net: NET_TX0_P0_to_RX0_P0 (width=100000nm, material=Copper)
* Net: NET_TX0_P1_to_RX0_P1 (width=100000nm, material=Copper)
* Net: NET_TX0_P2_to_RX0_P2 (width=100000nm, material=Copper)
* Net: NET_TX0_P3_to_RX0_P3 (width=100000nm, material=Copper)
* Net: NET_TX0_P4_to_RX0_P4 (width=100000nm, material=Copper)
* Net: NET_TX0_P5_to_RX0_P5 (width=100000nm, material=Copper)
* Net: NET_TX0_P6_to_RX0_P6 (width=100000nm, material=Copper)
* Net: NET_TX0_P7_to_RX0_P7 (width=100000nm, material=Copper)
* Net: NET_TX1_P0_to_RX1_P0 (width=100000nm, material=Copper)
* Net: NET_TX1_P1_to_RX1_P1 (width=100000nm, material=Copper)
* Net: NET_TX1_P2_to_RX1_P2 (width=100000nm, material=Copper)
* Net: NET_TX1_P3_to_RX1_P3 (width=100000nm, material=Copper)
* Net: NET_TX1_P4_to_RX1_P4 (width=100000nm, material=Copper)
* Net: NET_TX1_P5_to_RX1_P5 (width=100000nm, material=Copper)
* Net: NET_TX1_P6_to_RX1_P6 (width=100000nm, material=Copper)
* Net: NET_TX1_P7_to_RX1_P7 (width=100000nm, material=Copper)
* Net: NET_TX2_P0_to_RX2_P0 (width=100000nm, material=Copper)
* Net: NET_TX2_P1_to_RX2_P1 (width=100000nm, material=Copper)
* Net: NET_TX2_P2_to_RX2_P2 (width=100000nm, material=Copper)
* Net: NET_TX2_P3_to_RX2_P3 (width=100000nm, material=Copper)
* Net: NET_TX2_P4_to_RX2_P4 (width=100000nm, material=Copper)
* Net: NET_TX2_P5_to_RX2_P5 (width=100000nm, material=Copper)
* Net: NET_TX2_P6_to_RX2_P6 (width=100000nm, material=Copper)
* Net: NET_TX2_P7_to_RX2_P7 (width=100000nm, material=Copper)
* Net: NET_TX3_P0_to_RX3_P0 (width=100000nm, material=Copper)
* Net: NET_TX3_P1_to_RX3_P1 (width=100000nm, material=Copper)
* Net: NET_TX3_P2_to_RX3_P2 (width=100000nm, material=Copper)
* Net: NET_TX3_P3_to_RX3_P3 (width=100000nm, material=Copper)
* Net: NET_TX3_P4_to_RX3_P4 (width=100000nm, material=Copper)
* Net: NET_TX3_P5_to_RX3_P5 (width=100000nm, material=Copper)
* Net: NET_TX3_P6_to_RX3_P6 (width=100000nm, material=Copper)
* Net: NET_TX3_P7_to_RX3_P7 (width=100000nm, material=Copper)
* Net: NET_TX4_P0_to_RX4_P0 (width=100000nm, material=Copper)
* Net: NET_TX4_P1_to_RX4_P1 (width=100000nm, material=Copper)
* Net: NET_TX4_P2_to_RX4_P2 (width=100000nm, material=Copper)
* Net: NET_TX4_P3_to_RX4_P3 (width=100000nm, material=Copper)
* Net: NET_TX4_P4_to_RX4_P4 (width=100000nm, material=Copper)
* Net: NET_TX4_P5_to_RX4_P5 (width=100000nm, material=Copper)
* Net: NET_TX4_P6_to_RX4_P6 (width=100000nm, material=Copper)
* Net: NET_TX4_P7_to_RX4_P7 (width=100000nm, material=Copper)
* Net: NET_TX5_P0_to_RX5_P0 (width=100000nm, material=Copper)
* Net: NET_TX5_P1_to_RX5_P1 (width=100000nm, material=Copper)
* Net: NET_TX5_P2_to_RX5_P2 (width=100000nm, material=Copper)
* Net: NET_TX5_P3_to_RX5_P3 (width=100000nm, material=Copper)
* Net: NET_TX5_P4_to_RX5_P4 (width=100000nm, material=Copper)
* Net: NET_TX5_P5_to_RX5_P5 (width=100000nm, material=Copper)
* Net: NET_TX5_P6_to_RX5_P6 (width=100000nm, material=Copper)
* Net: NET_TX5_P7_to_RX5_P7 (width=100000nm, material=Copper)
* Net: NET_TX6_P0_to_RX6_P0 (width=100000nm, material=Copper)
* Net: NET_TX6_P1_to_RX6_P1 (width=100000nm, material=Copper)
* Net: NET_TX6_P2_to_RX6_P2 (width=100000nm, material=Copper)
* Net: NET_TX6_P3_to_RX6_P3 (width=100000nm, material=Copper)
* Net: NET_TX6_P4_to_RX6_P4 (width=100000nm, material=Copper)
* Net: NET_TX6_P5_to_RX6_P5 (width=100000nm, material=Copper)
* Net: NET_TX6_P6_to_RX6_P6 (width=100000nm, material=Copper)
* Net: NET_TX6_P7_to_RX6_P7 (width=100000nm, material=Copper)
* Net: NET_TX7_P0_to_RX7_P0 (width=100000nm, material=Copper)
* Net: NET_TX7_P1_to_RX7_P1 (width=100000nm, material=Copper)
* Net: NET_TX7_P2_to_RX7_P2 (width=100000nm, material=Copper)
* Net: NET_TX7_P3_to_RX7_P3 (width=100000nm, material=Copper)
* Net: NET_TX7_P4_to_RX7_P4 (width=100000nm, material=Copper)
* Net: NET_TX7_P5_to_RX7_P5 (width=100000nm, material=Copper)
* Net: NET_TX7_P6_to_RX7_P6 (width=100000nm, material=Copper)
* Net: NET_TX7_P7_to_RX7_P7 (width=100000nm, material=Copper)
* Net: NET_TX8_P0_to_RX8_P0 (width=100000nm, material=Copper)
* Net: NET_TX8_P1_to_RX8_P1 (width=100000nm, material=Copper)
* Net: NET_TX8_P2_to_RX8_P2 (width=100000nm, material=Copper)
* Net: NET_TX8_P3_to_RX8_P3 (width=100000nm, material=Copper)
* Net: NET_TX8_P4_to_RX8_P4 (width=100000nm, material=Copper)
* Net: NET_TX8_P5_to_RX8_P5 (width=100000nm, material=Copper)
* Net: NET_TX8_P6_to_RX8_P6 (width=100000nm, material=Copper)
* Net: NET_TX8_P7_to_RX8_P7 (width=100000nm, material=Copper)
* Net: NET_TX9_P0_to_RX9_P0 (width=100000nm, material=Copper)
* Net: NET_TX9_P1_to_RX9_P1 (width=100000nm, material=Copper)
* Net: NET_TX9_P2_to_RX9_P2 (width=100000nm, material=Copper)
* Net: NET_TX9_P3_to_RX9_P3 (width=100000nm, material=Copper)
* Net: NET_TX9_P4_to_RX9_P4 (width=100000nm, material=Copper)
* Net: NET_TX9_P5_to_RX9_P5 (width=100000nm, material=Copper)
* Net: NET_TX9_P6_to_RX9_P6 (width=100000nm, material=Copper)
* Net: NET_TX9_P7_to_RX9_P7 (width=100000nm, material=Copper)
* Net: NET_TX10_P0_to_RX10_P0 (width=100000nm, material=Copper)
* Net: NET_TX10_P1_to_RX10_P1 (width=100000nm, material=Copper)
* Net: NET_TX10_P2_to_RX10_P2 (width=100000nm, material=Copper)
* Net: NET_TX10_P3_to_RX10_P3 (width=100000nm, material=Copper)
* Net: NET_TX10_P4_to_RX10_P4 (width=100000nm, material=Copper)
* Net: NET_TX10_P5_to_RX10_P5 (width=100000nm, material=Copper)
* Net: NET_TX10_P6_to_RX10_P6 (width=100000nm, material=Copper)
* Net: NET_TX10_P7_to_RX10_P7 (width=100000nm, material=Copper)
* Net: NET_TX11_P0_to_RX11_P0 (width=100000nm, material=Copper)
* Net: NET_TX11_P1_to_RX11_P1 (width=100000nm, material=Copper)
* Net: NET_TX11_P2_to_RX11_P2 (width=100000nm, material=Copper)
* Net: NET_TX11_P3_to_RX11_P3 (width=100000nm, material=Copper)
* Net: NET_TX11_P4_to_RX11_P4 (width=100000nm, material=Copper)
* Net: NET_TX11_P5_to_RX11_P5 (width=100000nm, material=Copper)
* Net: NET_TX11_P6_to_RX11_P6 (width=100000nm, material=Copper)
* Net: NET_TX11_P7_to_RX11_P7 (width=100000nm, material=Copper)
* Net: NET_TX12_P0_to_RX12_P0 (width=100000nm, material=Copper)
* Net: NET_TX12_P1_to_RX12_P1 (width=100000nm, material=Copper)
* Net: NET_TX12_P2_to_RX12_P2 (width=100000nm, material=Copper)
* Net: NET_TX12_P3_to_RX12_P3 (width=100000nm, material=Copper)
* Net: NET_TX12_P4_to_RX12_P4 (width=100000nm, material=Copper)
* Net: NET_TX12_P5_to_RX12_P5 (width=100000nm, material=Copper)
* Net: NET_TX12_P6_to_RX12_P6 (width=100000nm, material=Copper)
* Net: NET_TX12_P7_to_RX12_P7 (width=100000nm, material=Copper)
* Net: NET_TX13_P0_to_RX13_P0 (width=100000nm, material=Copper)
* Net: NET_TX13_P1_to_RX13_P1 (width=100000nm, material=Copper)
* Net: NET_TX13_P2_to_RX13_P2 (width=100000nm, material=Copper)
* Net: NET_TX13_P3_to_RX13_P3 (width=100000nm, material=Copper)
* Net: NET_TX13_P4_to_RX13_P4 (width=100000nm, material=Copper)
* Net: NET_TX13_P5_to_RX13_P5 (width=100000nm, material=Copper)
* Net: NET_TX13_P6_to_RX13_P6 (width=100000nm, material=Copper)
* Net: NET_TX13_P7_to_RX13_P7 (width=100000nm, material=Copper)
* Net: NET_TX14_P0_to_RX14_P0 (width=100000nm, material=Copper)
* Net: NET_TX14_P1_to_RX14_P1 (width=100000nm, material=Copper)
* Net: NET_TX14_P2_to_RX14_P2 (width=100000nm, material=Copper)
* Net: NET_TX14_P3_to_RX14_P3 (width=100000nm, material=Copper)
* Net: NET_TX14_P4_to_RX14_P4 (width=100000nm, material=Copper)
* Net: NET_TX14_P5_to_RX14_P5 (width=100000nm, material=Copper)
* Net: NET_TX14_P6_to_RX14_P6 (width=100000nm, material=Copper)
* Net: NET_TX14_P7_to_RX14_P7 (width=100000nm, material=Copper)
* Net: NET_TX15_P0_to_RX15_P0 (width=100000nm, material=Copper)
* Net: NET_TX15_P1_to_RX15_P1 (width=100000nm, material=Copper)
* Net: NET_TX15_P2_to_RX15_P2 (width=100000nm, material=Copper)
* Net: NET_TX15_P3_to_RX15_P3 (width=100000nm, material=Copper)
* Net: NET_TX15_P4_to_RX15_P4 (width=100000nm, material=Copper)
* Net: NET_TX15_P5_to_RX15_P5 (width=100000nm, material=Copper)
* Net: NET_TX15_P6_to_RX15_P6 (width=100000nm, material=Copper)

* ========================================
* COMPONENTS
* ========================================
XTX0 NET_TX0_P0_to_RX0_P0 NET_TX0_P1_to_RX0_P1 NET_TX0_P2_to_RX0_P2 NET_TX0_P3_to_RX0_P3 NET_TX0_P4_to_RX0_P4 NET_TX0_P5_to_RX0_P5 NET_TX0_P6_to_RX0_P6 NET_TX0_P7_to_RX0_P7 Bus8
XTX1 NET_TX1_P0_to_RX1_P0 NET_TX1_P1_to_RX1_P1 NET_TX1_P2_to_RX1_P2 NET_TX1_P3_to_RX1_P3 NET_TX1_P4_to_RX1_P4 NET_TX1_P5_to_RX1_P5 NET_TX1_P6_to_RX1_P6 NET_TX1_P7_to_RX1_P7 Bus8
XTX2 NET_TX2_P0_to_RX2_P0 NET_TX2_P1_to_RX2_P1 NET_TX2_P2_to_RX2_P2 NET_TX2_P3_to_RX2_P3 NET_TX2_P4_to_RX2_P4 NET_TX2_P5_to_RX2_P5 NET_TX2_P6_to_RX2_P6 NET_TX2_P7_to_RX2_P7 Bus8
XTX3 NET_TX3_P0_to_RX3_P0 NET_TX3_P1_to_RX3_P1 NET_TX3_P2_to_RX3_P2 NET_TX3_P3_to_RX3_P3 NET_TX3_P4_to_RX3_P4 NET_TX3_P5_to_RX3_P5 NET_TX3_P6_to_RX3_P6 NET_TX3_P7_to_RX3_P7 Bus8
XTX4 NET_TX4_P0_to_RX4_P0 NET_TX4_P1_to_RX4_P1 NET_TX4_P2_to_RX4_P2 NET_TX4_P3_to_RX4_P3 NET_TX4_P4_to_RX4_P4 NET_TX4_P5_to_RX4_P5 NET_TX4_P6_to_RX4_P6 NET_TX4_P7_to_RX4_P7 Bus8
XTX5 NET_TX5_P0_to_RX5_P0 NET_TX5_P1_to_RX5_P1 NET_TX5_P2_to_RX5_P2 NET_TX5_P3_to_RX5_P3 NET_TX5_P4_to_RX5_P4 NET_TX5_P5_to_RX5_P5 NET_TX5_P6_to_RX5_P6 NET_TX5_P7_to_RX5_P7 Bus8
XTX6 NET_TX6_P0_to_RX6_P0 NET_TX6_P1_to_RX6_P1 NET_TX6_P2_to_RX6_P2 NET_TX6_P3_to_RX6_P3 NET_TX6_P4_to_RX6_P4 NET_TX6_P5_to_RX6_P5 NET_TX6_P6_to_RX6_P6 NET_TX6_P7_to_RX6_P7 Bus8
XTX7 NET_TX7_P0_to_RX7_P0 NET_TX7_P1_to_RX7_P1 NET_TX7_P2_to_RX7_P2 NET_TX7_P3_to_RX7_P3 NET_TX7_P4_to_RX7_P4 NET_TX7_P5_to_RX7_P5 NET_TX7_P6_to_RX7_P6 NET_TX7_P7_to_RX7_P7 Bus8
XTX8 NET_TX8_P0_to_RX8_P0 NET_TX8_P1_to_RX8_P1 NET_TX8_P2_to_RX8_P2 NET_TX8_P3_to_RX8_P3 NET_TX8_P4_to_RX8_P4 NET_TX8_P5_to_RX8_P5 NET_TX8_P6_to_RX8_P6 NET_TX8_P7_to_RX8_P7 Bus8
XTX9 NET_TX9_P0_to_RX9_P0 NET_TX9_P1_to_RX9_P1 NET_TX9_P2_to_RX9_P2 NET_TX9_P3_to_RX9_P3 NET_TX9_P4_to_RX9_P4 NET_TX9_P5_to_RX9_P5 NET_TX9_P6_to_RX9_P6 NET_TX9_P7_to_RX9_P7 Bus8
XTX10 NET_TX10_P0_to_RX10_P0 NET_TX10_P1_to_RX10_P1 NET_TX10_P2_to_RX10_P2 NET_TX10_P3_to_RX10_P3 NET_TX10_P4_to_RX10_P4 NET_TX10_P5_to_RX10_P5 NET_TX10_P6_to_RX10_P6 NET_TX10_P7_to_RX10_P7 Bus8
XTX11 NET_TX11_P0_to_RX11_P0 NET_TX11_P1_to_RX11_P1 NET_TX11_P2_to_RX11_P2 NET_TX11_P3_to_RX11_P3 NET_TX11_P4_to_RX11_P4 NET_TX11_P5_to_RX11_P5 NET_TX11_P6_to_RX11_P6 NET_TX11_P7_to_RX11_P7 Bus8
XTX12 NET_TX12_P0_to_RX12_P0 NET_TX12_P1_to_RX12_P1 NET_TX12_P2_to_RX12_P2 NET_TX12_P3_to_RX12_P3 NET_TX12_P4_to_RX12_P4 NET_TX12_P5_to_RX12_P5 NET_TX12_P6_to_RX12_P6 NET_TX12_P7_to_RX12_P7 Bus8
XTX13 NET_TX13_P0_to_RX13_P0 NET_TX13_P1_to_RX13_P1 NET_TX13_P2_to_RX13_P2 NET_TX13_P3_to_RX13_P3 NET_TX13_P4_to_RX13_P4 NET_TX13_P5_to_RX13_P5 NET_TX13_P6_to_RX13_P6 NET_TX13_P7_to_RX13_P7 Bus8
XTX14 NET_TX14_P0_to_RX14_P0 NET_TX14_P1_to_RX14_P1 NET_TX14_P2_to_RX14_P2 NET_TX14_P3_to_RX14_P3 NET_TX14_P4_to_RX14_P4 NET_TX14_P5_to_RX14_P5 NET_TX14_P6_to_RX14_P6 NET_TX14_P7_to_RX14_P7 Bus8
XTX15 NET_TX15_P0_to_RX15_P0 NET_TX15_P1_to_RX15_P1 NET_TX15_P2_to_RX15_P2 NET_TX15_P3_to_RX15_P3 NET_TX15_P4_to_RX15_P4 NET_TX15_P5_to_RX15_P5 NET_TX15_P6_to_RX15_P6 NET_TX15_P7_to_RX15_P7 Bus8
XRX0 NET_TX0_P0_to_RX0_P0 NET_TX0_P1_to_RX0_P1 NET_TX0_P2_to_RX0_P2 NET_TX0_P3_to_RX0_P3 NET_TX0_P4_to_RX0_P4 NET_TX0_P5_to_RX0_P5 NET_TX0_P6_to_RX0_P6 NET_TX0_P7_to_RX0_P7 Bus8
XRX1 NET_TX1_P0_to_RX1_P0 NET_TX1_P1_to_RX1_P1 NET_TX1_P2_to_RX1_P2 NET_TX1_P3_to_RX1_P3 NET_TX1_P4_to_RX1_P4 NET_TX1_P5_to_RX1_P5 NET_TX1_P6_to_RX1_P6 NET_TX1_P7_to_RX1_P7 Bus8
XRX2 NET_TX2_P0_to_RX2_P0 NET_TX2_P1_to_RX2_P1 NET_TX2_P2_to_RX2_P2 NET_TX2_P3_to_RX2_P3 NET_TX2_P4_to_RX2_P4 NET_TX2_P5_to_RX2_P5 NET_TX2_P6_to_RX2_P6 NET_TX2_P7_to_RX2_P7 Bus8
XRX3 NET_TX3_P0_to_RX3_P0 NET_TX3_P1_to_RX3_P1 NET_TX3_P2_to_RX3_P2 NET_TX3_P3_to_RX3_P3 NET_TX3_P4_to_RX3_P4 NET_TX3_P5_to_RX3_P5 NET_TX3_P6_to_RX3_P6 NET_TX3_P7_to_RX3_P7 Bus8
XRX4 NET_TX4_P0_to_RX4_P0 NET_TX4_P1_to_RX4_P1 NET_TX4_P2_to_RX4_P2 NET_TX4_P3_to_RX4_P3 NET_TX4_P4_to_RX4_P4 NET_TX4_P5_to_RX4_P5 NET_TX4_P6_to_RX4_P6 NET_TX4_P7_to_RX4_P7 Bus8
XRX5 NET_TX5_P0_to_RX5_P0 NET_TX5_P1_to_RX5_P1 NET_TX5_P2_to_RX5_P2 NET_TX5_P3_to_RX5_P3 NET_TX5_P4_to_RX5_P4 NET_TX5_P5_to_RX5_P5 NET_TX5_P6_to_RX5_P6 NET_TX5_P7_to_RX5_P7 Bus8
XRX6 NET_TX6_P0_to_RX6_P0 NET_TX6_P1_to_RX6_P1 NET_TX6_P2_to_RX6_P2 NET_TX6_P3_to_RX6_P3 NET_TX6_P4_to_RX6_P4 NET_TX6_P5_to_RX6_P5 NET_TX6_P6_to_RX6_P6 NET_TX6_P7_to_RX6_P7 Bus8
XRX7 NET_TX7_P0_to_RX7_P0 NET_TX7_P1_to_RX7_P1 NET_TX7_P2_to_RX7_P2 NET_TX7_P3_to_RX7_P3 NET_TX7_P4_to_RX7_P4 NET_TX7_P5_to_RX7_P5 NET_TX7_P6_to_RX7_P6 NET_TX7_P7_to_RX7_P7 Bus8
XRX8 NET_TX8_P0_to_RX8_P0 NET_TX8_P1_to_RX8_P1 NET_TX8_P2_to_RX8_P2 NET_TX8_P3_to_RX8_P3 NET_TX8_P4_to_RX8_P4 NET_TX8_P5_to_RX8_P5 NET_TX8_P6_to_RX8_P6 NET_TX8_P7_to_RX8_P7 Bus8
XRX9 NET_TX9_P0_to_RX9_P0 NET_TX9_P1_to_RX9_P1 NET_TX9_P2_to_RX9_P2 NET_TX9_P3_to_RX9_P3 NET_TX9_P4_to_RX9_P4 NET_TX9_P5_to_RX9_P5 NET_TX9_P6_to_RX9_P6 NET_TX9_P7_to_RX9_P7 Bus8
XRX10 NET_TX10_P0_to_RX10_P0 NET_TX10_P1_to_RX10_P1 NET_TX10_P2_to_RX10_P2 NET_TX10_P3_to_RX10_P3 NET_TX10_P4_to_RX10_P4 NET_TX10_P5_to_RX10_P5 NET_TX10_P6_to_RX10_P6 NET_TX10_P7_to_RX10_P7 Bus8
XRX11 NET_TX11_P0_to_RX11_P0 NET_TX11_P1_to_RX11_P1 NET_TX11_P2_to_RX11_P2 NET_TX11_P3_to_RX11_P3 NET_TX11_P4_to_RX11_P4 NET_TX11_P5_to_RX11_P5 NET_TX11_P6_to_RX11_P6 NET_TX11_P7_to_RX11_P7 Bus8
XRX12 NET_TX12_P0_to_RX12_P0 NET_TX12_P1_to_RX12_P1 NET_TX12_P2_to_RX12_P2 NET_TX12_P3_to_RX12_P3 NET_TX12_P4_to_RX12_P4 NET_TX12_P5_to_RX12_P5 NET_TX12_P6_to_RX12_P6 NET_TX12_P7_to_RX12_P7 Bus8
XRX13 NET_TX13_P0_to_RX13_P0 NET_TX13_P1_to_RX13_P1 NET_TX13_P2_to_RX13_P2 NET_TX13_P3_to_RX13_P3 NET_TX13_P4_to_RX13_P4 NET_TX13_P5_to_RX13_P5 NET_TX13_P6_to_RX13_P6 NET_TX13_P7_to_RX13_P7 Bus8
XRX14 NET_TX14_P0_to_RX14_P0 NET_TX14_P1_to_RX14_P1 NET_TX14_P2_to_RX14_P2 NET_TX14_P3_to_RX14_P3 NET_TX14_P4_to_RX14_P4 NET_TX14_P5_to_RX14_P5 NET_TX14_P6_to_RX14_P6 NET_TX14_P7_to_RX14_P7 Bus8
XRX15 NET_TX15_P0_to_RX15_P0 NET_TX15_P1_to_RX15_P1 NET_TX15_P2_to_RX15_P2 NET_TX15_P3_to_RX15_P3 NET_TX15_P4_to_RX15_P4 NET_TX15_P5_to_RX15_P5 NET_TX15_P6_to_RX15_P6 NET_TX15_P7_to_RX15_P7 Bus8

* ========================================
* DEVICE EXTRACTION REQUIRES EXPLICIT BINDINGS
* Use 'device: DeviceName.terminal' property
* ========================================

.end
