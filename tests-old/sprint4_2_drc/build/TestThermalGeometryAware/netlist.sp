* Hardware Script Native Netlist: TestThermalGeometryAware
* Generated by hwc v0.1.6 (Syntax Unification)
* Format: SPICE3

* ========================================
* NETS
* ========================================
* Net: Ground (pour: GroundPlane, material: Copper, layer: 1)
* Net: Power (pour: PowerPlane, material: Copper, layer: 18)
* Net: Ground (width=100000nm, material=Copper)

* ========================================
* COMPONENTS
* ========================================
XGroundPlane Ground Pour(Copper)
XPowerPlane Power Pour(Copper)

* ========================================
* DEVICE EXTRACTION REQUIRES EXPLICIT BINDINGS
* Use 'device: DeviceName.terminal' property
* ========================================

.end
