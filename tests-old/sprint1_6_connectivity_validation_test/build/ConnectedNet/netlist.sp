* Hardware Script Native Netlist: ConnectedNet
* Generated by hwc v0.1.6 (Syntax Unification)
* Format: SPICE3

* ========================================
* NETS
* ========================================
* Net: VDD (pour: Pour_A, material: TestMetal, layer: 7)
* Net: VDD (pour: Pour_B, material: TestMetal, layer: 7)
* Net: VDD (width=100000nm, material=TestMetal)
*   Connected pins:
*     - Pour_A.anchor
*     - Pour_B.anchor

* ========================================
* COMPONENTS
* ========================================
XPour_A VDD Pour(TestMetal)
XPour_B VDD Pour(TestMetal)

* ========================================
* DEVICE EXTRACTION REQUIRES EXPLICIT BINDINGS
* Use 'device: DeviceName.terminal' property
* ========================================

.end
