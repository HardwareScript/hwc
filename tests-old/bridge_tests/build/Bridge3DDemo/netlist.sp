* Hardware Script Native Netlist: Bridge3DDemo
* Generated by hwc v0.1.6 (Syntax Unification)
* Format: SPICE3

* ========================================
* NETS
* ========================================
* Net: ROAD (pour: Ground_Left, material: Copper, layer: 1)
* Net: ROAD (pour: Ground_Right, material: Copper, layer: 1)
* Net: ROAD (pour: Elevated_Road, material: Copper, layer: 5)

* ========================================
* COMPONENTS
* ========================================
XGround_Left ROAD Pour(Copper)
XGround_Right ROAD Pour(Copper)
XElevated_Road ROAD Pour(Copper)
XVia_1_5 ROAD Contact(Copper)
XVia_1_5 ROAD Contact(Copper)
XAutoVia_ROAD_1_2 ROAD Contact(Copper)
XAutoVia_ROAD_2_3 ROAD Contact(Copper)
XAutoVia_ROAD_3_4 ROAD Contact(Copper)
XAutoVia_ROAD_4_5 ROAD Contact(Copper)
XAutoVia_ROAD_1_2 ROAD Contact(Copper)
XAutoVia_ROAD_2_3 ROAD Contact(Copper)
XAutoVia_ROAD_3_4 ROAD Contact(Copper)
XAutoVia_ROAD_4_5 ROAD Contact(Copper)

.end
