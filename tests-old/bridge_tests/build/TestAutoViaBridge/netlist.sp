* Hardware Script Native Netlist: TestAutoViaBridge
* Generated by hwc v0.1.6 (Syntax Unification)
* Format: SPICE3

* ========================================
* NETS
* ========================================
* Net: VDD (pour: VDD_Metal1, material: Copper, layer: 1)
* Net: VDD (pour: VDD_Metal2, material: Copper, layer: 2)

* ========================================
* COMPONENTS
* ========================================
XVDD_Metal1 VDD Pour(Copper)
XVDD_Metal2 VDD Pour(Copper)
XAutoVia_VDD_1_2 VDD Contact(Copper)

.end
