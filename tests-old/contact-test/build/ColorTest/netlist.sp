* Hardware Script Native Netlist: ColorTest
* Generated by hwc v0.1.6 (Syntax Unification)
* Format: SPICE3

* ========================================
* NETS
* ========================================
* Net: RED (pour: Red, material: RedBox, layer: 2)
* Net: GREEN (pour: Green, material: GreenBox, layer: 4)
* Net: BLUE (pour: Blue, material: BlueBox, layer: 6)
* Net: YELLOW (pour: Yellow, material: YellowBox, layer: 8)
* Net: MAGENTA (pour: Magenta, material: MagentaBox, layer: 10)
* Net: RED (width=100000nm, material=RedBox)
*   Connected pins:
*     - Red.anchor
* Net: GREEN (width=100000nm, material=GreenBox)
*   Connected pins:
*     - Green.anchor
* Net: BLUE (width=100000nm, material=BlueBox)
*   Connected pins:
*     - Blue.anchor
* Net: YELLOW (width=100000nm, material=YellowBox)
*   Connected pins:
*     - Yellow.anchor
* Net: MAGENTA (width=100000nm, material=MagentaBox)
*   Connected pins:
*     - Magenta.anchor

* ========================================
* COMPONENTS
* ========================================
XRed RED Pour(RedBox)
XGreen GREEN Pour(GreenBox)
XBlue BLUE Pour(BlueBox)
XYellow YELLOW Pour(YellowBox)
XMagenta MAGENTA Pour(MagentaBox)

.end
