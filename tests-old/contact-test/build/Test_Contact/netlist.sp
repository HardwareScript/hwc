* Hardware Script Native Netlist: Test_Contact
* Generated by hwc v0.1.6 (Syntax Unification)
* Format: SPICE3

* ========================================
* NETS
* ========================================
* Net: GATE (pour: Gate, material: Polysilicon, layer: 6)
* Net: GATE (pour: Metal, material: Aluminum, layer: 8)
* Net: GATE (width=100000nm, material=Polysilicon)
*   Connected pins:
*     - Gate.anchor
*     - Metal.anchor
*     - Via1.via
*     - Via_6_8.via

* ========================================
* COMPONENTS
* ========================================
XGate GATE Pour(Polysilicon)
XMetal GATE Pour(Aluminum)
XVia1 GATE Contact(Tungsten)
XVia_6_8 GATE Contact(Tungsten)

.end
