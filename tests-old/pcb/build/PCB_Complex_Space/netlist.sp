* Hardware Script Native Netlist: PCB_Complex_Space
* Generated by hwc v0.1.6 (Syntax Unification)
* Format: SPICE3

* ========================================
* NETS
* ========================================
* Net: NET_MANUAL (width=200000nm, material=FR4)

* ========================================
* COMPONENTS
* ========================================
XJ1_S NET_MANUAL Pad
XJ1_D NET_MANUAL Pad
XJ2_S NET_AUTO Pad
XJ2_D NET_AUTO Pad

* ========================================
* DEVICE EXTRACTION REQUIRES EXPLICIT BINDINGS
* Use 'device: DeviceName.terminal' property
* ========================================

.end
