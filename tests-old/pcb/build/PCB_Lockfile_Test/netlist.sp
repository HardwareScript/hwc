* Hardware Script Native Netlist: PCB_Lockfile_Test
* Generated by hwc v0.1.6 (Syntax Unification)
* Format: SPICE3

* ========================================
* NETS
* ========================================
* Net: NET_A (pour: Pad_J1, material: Copper, z: 0.0000mm)
* Net: NET_A (pour: Pad_J2, material: Copper, z: 0.0000mm)
* Net: NET_A (pour: Pad_J3, material: Copper, z: 0.0000mm)
* Net: NET_B (pour: Pad_J4, material: Copper, z: 0.0000mm)
* Net: NET_B (pour: Pad_J5, material: Copper, z: 0.0000mm)
* Net: NET_B (pour: Pad_J6, material: Copper, z: 0.0000mm)
* Net: NET_A (width=100000nm, material=Copper)

* ========================================
* COMPONENTS
* ========================================
XPad_J1 NET_A Pour(Copper)
XPad_J2 NET_A Pour(Copper)
XPad_J3 NET_A Pour(Copper)
XPad_J4 NET_B Pour(Copper)
XPad_J5 NET_B Pour(Copper)
XPad_J6 NET_B Pour(Copper)
XJ1 NET_A Pad
XJ2 NET_A Pad
XJ3 NET_A Pad
XJ4 NET_B Pad
XJ5 NET_B Pad
XJ6 NET_B Pad

* ========================================
* DEVICE EXTRACTION REQUIRES EXPLICIT BINDINGS
* Use 'device: DeviceName.terminal' property
* ========================================

.end
