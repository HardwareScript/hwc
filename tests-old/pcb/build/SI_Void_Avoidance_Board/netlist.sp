* Hardware Script Native Netlist: SI_Void_Avoidance_Board
* Generated by hwc v0.1.6 (Syntax Unification)
* Format: SPICE3

* ========================================
* NETS
* ========================================
* Net: CLK (width=200000nm, material=FR4)

* ========================================
* COMPONENTS
* ========================================
XR1 CLK Pad
XR2 CLK Pad
XR3 DATA Pad
XR4 DATA Pad

* ========================================
* DEVICE EXTRACTION REQUIRES EXPLICIT BINDINGS
* Use 'device: DeviceName.terminal' property
* ========================================

.end
