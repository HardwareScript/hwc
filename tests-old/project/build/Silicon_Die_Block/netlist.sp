* Hardware Script Native Netlist: Silicon_Die_Block
* Generated by hwc v0.1.6 (Syntax Unification)
* Format: SPICE3

* ========================================
* NETS
* ========================================
* Net: NET_G1_p_to_G2_p (width=100000nm, material=Copper)
* Net: NET_S1_p_to_S2_p (width=100000nm, material=Copper)
*   Connected pins:
*     - G2.p
*     - G3.p
*     - G2.p
*     - G3.p
* Net: NET_D1_p_to_D2_p (width=100000nm, material=Copper)
*   Connected pins:
*     - S2.p
*     - S3.p
*     - S2.p
*     - S3.p

* ========================================
* COMPONENTS
* ========================================
XG1 NET_G1_p_to_G2_p Pad
XS1 NET_S1_p_to_S2_p Pad
XD1 NET_D1_p_to_D2_p Pad
XB1 NET_B1_p_to_B2_p Pad
XG2 NET_G1_p_to_G2_p Pad
XS2 NET_S1_p_to_S2_p Pad
XD2 NET_D1_p_to_D2_p Pad
XB2 NET_B1_p_to_B2_p Pad
XG3 NET_G1_p_to_G2_p Pad
XS3 NET_S1_p_to_S2_p Pad
XD3 NET_D1_p_to_D2_p Pad
XB3 NET_B1_p_to_B2_p Pad

* ========================================
* DEVICE EXTRACTION REQUIRES EXPLICIT BINDINGS
* Use 'device: DeviceName.terminal' property
* ========================================

.end
