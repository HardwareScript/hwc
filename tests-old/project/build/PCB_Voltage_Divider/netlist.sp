* Hardware Script Native Netlist: PCB_Voltage_Divider
* Generated by hwc v0.1.6 (Syntax Unification)
* Format: SPICE3

* ========================================
* NETS
* ========================================
* Net: VIN (pour: R1_A, material: Copper, z: 1.2350mm)
* Net: VOUT (pour: R1_B, material: Copper, z: 1.2350mm)
* Net: VOUT (pour: R2_A, material: Copper, z: 1.2350mm)
* Net: GND (pour: R2_B, material: Copper, z: 1.2350mm)
* Net: VIN (pour: VIN_Rail, material: Copper, z: 1.2350mm)
* Net: GND (pour: GND_Rail, material: Copper, z: 1.2350mm)
* Net: VIN (width=100000nm, material=Copper)
* Net: VOUT (width=100000nm, material=Copper)
*   Connected pins:
*     - VIN_Rail.anchor
*     - R1_A.anchor
*     - VIN_Rail.anchor

* ========================================
* COMPONENTS
* ========================================
XR1_A VIN Pour(Copper)
XR1_B VOUT Pour(Copper)
XR2_A VOUT Pour(Copper)
XR2_B GND Pour(Copper)
XVIN_Rail VIN Pour(Copper)
XGND_Rail GND Pour(Copper)

* ========================================
* DEVICE EXTRACTION REQUIRES EXPLICIT BINDINGS
* Use 'device: DeviceName.terminal' property
* ========================================

.end
