* Hardware Script Native Netlist: PowerRegulatorBoard
* Generated by hwc v0.1.6 (Syntax Unification)
* Format: SPICE3

* ========================================
* NETS
* ========================================
* Net: GND (pour: GND_Plane, material: Copper, layer: 9)

* ========================================
* COMPONENTS
* ========================================
XU1 nc_0 nc_1 nc_2 TO220
XQ1 nc_3 nc_4 nc_5 SOT23
XQ2 nc_6 nc_7 nc_8 nc_9 SOT223
XM1 nc_10 MountingHole_3mm
XM2 nc_11 MountingHole_3mm
XM3 nc_12 MountingHole_3mm
XM4 nc_13 MountingHole_3mm
XFID1 nc_14 Fiducial_1mm
XFID2 nc_15 Fiducial_1mm
XGND_Plane GND Pour(Copper)

* ========================================
* DEVICE EXTRACTION REQUIRES EXPLICIT BINDINGS
* Use 'device: DeviceName.terminal' property
* ========================================

.end
