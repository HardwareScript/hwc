* Hardware Script Native Netlist: TestPourChaining
* Generated by hwc v0.1.6 (Syntax Unification)
* Format: SPICE3

* ========================================
* NETS
* ========================================
* Net: VDD (pour: PowerRail_0, material: Copper, layer: 1)
* Net: VDD (pour: PowerRail_1, material: Copper, layer: 1)
* Net: VDD (pour: PowerRail_2, material: Copper, layer: 1)
* Net: VDD (pour: PowerRail_3, material: Copper, layer: 1)

* ========================================
* COMPONENTS
* ========================================
XPowerRail_0 VDD Pour(Copper)
XPowerRail_1 VDD Pour(Copper)
XPowerRail_2 VDD Pour(Copper)
XPowerRail_3 VDD Pour(Copper)

* ========================================
* DEVICE EXTRACTION REQUIRES EXPLICIT BINDINGS
* Use 'device: DeviceName.terminal' property
* ========================================

.end
